Netlist for the Sum_Bit bit - (8)

.include "TSMC_180nm.txt"
.param SUPPLY = 1.8
.param LAMBDA = 0.09u
.param width_N = {20 * LAMBDA} ; Vary the width (1)
.param width_P = {2 * width_N} ; Assuming ratio of mobilites is 2, change it (2)
.global gnd vdd

.subckt Inverter in out high low
    M1 high in out high CMOSP W={width_P} L={2*LAMBDA}
    + AS={5*width_P*LAMBDA} PS={10*LAMBDA+2*width_P} AD={5*width_P*LAMBDA} PD={10*LAMBDA+2*width_P}
    M2 out in low low CMOSN W={width_N} L={2*LAMBDA}
    + AS={5*width_N*LAMBDA} PS={10*LAMBDA+2*width_N} AD={5*width_N*LAMBDA} PD={10*LAMBDA+2*width_N}
.ends Inverter

* Modified the Widths to equalize the delay to a minimum sized inverter (3Wn)
.subckt Sum_Bit_Logic clk A_not B_not Cin_not Co out high low

    MS_PUN_01 high clk out high CMOSP W={width_P} L={2*LAMBDA}
    + AS={5*width_P*LAMBDA} PS={10*LAMBDA+2*width_P} AD={5*width_P*LAMBDA} PD={10*LAMBDA+2*width_P}

    * Keeper Circuit
    XKeeperInverter out outFinal vdd gnd Inverter
    MKeeper high outFinal out high CMOSP W = {width_P} L = {2*LAMBDA}
    + AS = {5*width_P*LAMBDA} PS = {10*LAMBDA+2*width_P} AD = {5*width_P*LAMBDA} PD = {10*LAMBDA+2*width_P}

    MS_PDN_01 out clk S_Inter_01 S_Inter_01 CMOSN W={4*width_N} L={2*LAMBDA}
    + AS={5*4*width_N*LAMBDA} PS={10*LAMBDA+2*4*width_N} AD={5*4*width_N*LAMBDA} PD={10*LAMBDA+2*4*width_N}

    MS_PDN_02 S_Inter_01 A_not S_Inter_02 S_Inter_02 CMOSN W={4*width_N} L={2*LAMBDA}
    + AS={5*4*width_N*LAMBDA} PS={10*LAMBDA+2*4*width_N} AD={5*4*width_N*LAMBDA} PD={10*LAMBDA+2*4*width_N}
    MS_PDN_03 S_Inter_02 B_not S_Inter_03 S_Inter_03 CMOSN W={4*width_N} L={2*LAMBDA}
    + AS={5*4*width_N*LAMBDA} PS={10*LAMBDA+2*4*width_N} AD={5*4*width_N*LAMBDA} PD={10*LAMBDA+2*4*width_N}
    MS_PDN_04 S_Inter_03 Cin_not low low CMOSN W={4*width_N} L={2*LAMBDA}
    + AS={5*4*width_N*LAMBDA} PS={10*LAMBDA+2*4*width_N} AD={5*4*width_N*LAMBDA} PD={10*LAMBDA+2*4*width_N}

    * 8/3 Wn approximated to 3Wn
    MS_PDN_05 S_Inter_01 Co S_Inter_04 S_Inter_04 CMOSN W={3*width_N} L={2*LAMBDA}
    + AS={5*3*width_N*LAMBDA} PS={10*LAMBDA+2*3*width_N} AD={5*3*width_N*LAMBDA} PD={10*LAMBDA+2*3*width_N}

    MS_PDN_06 S_Inter_04 A_not low low CMOSN W={3*width_N} L={2*LAMBDA}
    + AS={5*3*width_N*LAMBDA} PS={10*LAMBDA+2*3*width_N} AD={5*3*width_N*LAMBDA} PD={10*LAMBDA+2*3*width_N}
    MS_PDN_07 S_Inter_04 B_not low low CMOSN W={3*width_N} L={2*LAMBDA}
    + AS={5*3*width_N*LAMBDA} PS={10*LAMBDA+2*3*width_N} AD={5*3*width_N*LAMBDA} PD={10*LAMBDA+2*3*width_N}
    MS_PDN_08 S_Inter_04 Cin_not low low CMOSN W={3*width_N} L={2*LAMBDA}
    + AS={5*3*width_N*LAMBDA} PS={10*LAMBDA+2*3*width_N} AD={5*3*width_N*LAMBDA} PD={10*LAMBDA+2*3*width_N}

.ends Sum_Bit_Logic

* .subckt InverterLoad in out high low
*     M1 high in out high CMOSP W={20*LAMBDA} L={2*LAMBDA}
*     + AS={5*20*LAMBDA*LAMBDA} PS={10*LAMBDA+2*20*LAMBDA} AD={5*20*LAMBDA*LAMBDA} PD={10*LAMBDA+2*20*LAMBDA}
*     M2 out in low low CMOSN W={10*LAMBDA} L={2*LAMBDA}
*     + AS={5*10*LAMBDA*LAMBDA} PS={10*LAMBDA+2*10*LAMBDA} AD={5*10*LAMBDA*LAMBDA} PD={10*LAMBDA+2*10*LAMBDA}
* .ends InverterLoad

* vin in+ in- pulse VLow VHigh delay rise-time fall-time on-period time-period
VDD vdd gnd 'SUPPLY'
VClk clk_line gnd pulse gnd SUPPLY 0 1p 1p 1ns 2ns ; No Skew Currently, add a skew for practical measurements (3)
* VA_not A_not gnd pulse gnd SUPPLY 0.3n 1p 1p 2ns 4ns ; No Skew Currently, add a skew for practical measurements (4)
* VB_not B_not gnd pulse gnd SUPPLY 0.8n 1p 1p 3ns 6ns ; No Skew Currently, add a skew for practical measurements (5)
* VCin_not Cin_not gnd pulse gnd SUPPLY 1.3n 1p 1p 7ns 14ns ; No Skew Currently, add a skew for practical measurements (6)
* VC Co gnd pulse gnd SUPPLY 1.8n 1p 1p 15ns 30ns ; No Skew Currently, add a skew for practical measurements (7)

VA_not A_not gnd 0
VB_not B_not gnd 0
VCin_not Cin_not gnd 0
VC Co gnd 0

XSum_Bit_Logic clk_line A_not B_not Cin_not Co out vdd gnd Sum_Bit_Logic

* Load - (8)
* XInverterL out temp vdd gnd InverterLoad

* .measure tran trise
* + TRIG V(out) VAL = 'SUPPLY / 10' TD = 5ns TO = 15ns RISE = 1
* + TARG V(out) VAL = '9 * SUPPLY / 10' TD = 5ns TO = 15ns RISE = 1

* .measure tran tfall
* + TRIG V(out) VAL = '9 * SUPPLY / 10' TD = 25ns TO = 35ns FALL = 1
* + TARG V(out) VAL = 'SUPPLY / 10' TD = 25ns TO = 35ns FALL = 1

* .measure tran delay param = '(trise + tfall) / 2'

* .measure tran tcqrise
* + TRIG V(clk_line) VAL = 'SUPPLY / 2' RISE = 1
* + TARG V(out) VAL = 'SUPPLY / 2' RISE = 1

* .measure tran tcqfall
* + TRIG V(clk_line) VAL = 'SUPPLY / 2' RISE = 2
* + TARG V(out) VAL = 'SUPPLY / 2' FALL = 1

* .measure tran tcq param = '(tcqrise + tcqfall) / 2'

.tran 10ps 16ns

.control

run
set hcopypscolor = 1
set color0 = white
set color1 = black
set curplottitle = "Siddarth Gottumukkula 2023102040"
set xbrushwidth = 3
set ybrushwidth = 3

let clock = 'clk_line + 10'
let in_a0_bar = 'A_not + 8'
let in_b0_bar = 'B_not + 6'
let in_cin_bar = 'Cin_not + 4'
let Co = 'Co + 2'
let output = 'out'
plot clock in_a0_bar in_b0_bar in_cin_bar Co output

.endc

.end
