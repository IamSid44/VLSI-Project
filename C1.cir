Netlist for the C0 bit

.include "TSMC_180nm.txt"
.param SUPPLY = 1.8
.param LAMBDA = 0.09u
.param width_N = {20 * LAMBDA} ; Vary the width (1)
.param width_P = {2 * width_N} ; Assuming ratio of mobilites is 2, change it (2)
.global gnd vdd

.subckt C0_Bit_Logic clk A0_not B0_not Cin_not out high low

    MC0_PUN_01 high clk out high CMOSP W={width_P} L={2*LAMBDA}
    + AS={5*width_P*LAMBDA} PS={10*LAMBDA+2*width_P} AD={5*width_P*LAMBDA} PD={10*LAMBDA+2*width_P}

    MC0_PDN_01 out clk CO_Inter_03 CO_Inter_03 CMOSN W={width_N} L={2*LAMBDA}
    + AS={5*width_N*LAMBDA} PS={10*LAMBDA+2*width_N} AD={5*width_N*LAMBDA} PD={10*LAMBDA+2*width_N}

    MC0_PDN_06 CO_Inter_03 A0_not C0_Inter_02 C0_Inter_02 CMOSN W={width_N} L={2*LAMBDA}
    + AS={5*width_N*LAMBDA} PS={10*LAMBDA+2*width_N} AD={5*width_N*LAMBDA} PD={10*LAMBDA+2*width_N}
    MC0_PDN_05 C0_Inter_02 B0_not low low CMOSN W={width_N} L={2*LAMBDA}
    + AS={5*width_N*LAMBDA} PS={10*LAMBDA+2*width_N} AD={5*width_N*LAMBDA} PD={10*LAMBDA+2*width_N}

    MC0_PDN_04 CO_Inter_03 Cin_not C0_Inter_01 C0_Inter_01 CMOSN W={width_N} L={2*LAMBDA}
    + AS={5*width_N*LAMBDA} PS={10*LAMBDA+2*width_N} AD={5*width_N*LAMBDA} PD={10*LAMBDA+2*width_N}

    MC0_PDN_03 C0_Inter_01 A0_not low low CMOSN W={width_N} L={2*LAMBDA}
    + AS={5*width_N*LAMBDA} PS={10*LAMBDA+2*width_N} AD={5*width_N*LAMBDA} PD={10*LAMBDA+2*width_N}
    MC0_PDN_02 C0_Inter_01 B0_not low low CMOSN W={width_N} L={2*LAMBDA}
    + AS={5*width_N*LAMBDA} PS={10*LAMBDA+2*width_N} AD={5*width_N*LAMBDA} PD={10*LAMBDA+2*width_N}

.ends C0_Bit_Logic

* .subckt InverterLoad in out high low
*     M1 high in out high CMOSP W={20*LAMBDA} L={2*LAMBDA}
*     + AS={5*20*LAMBDA*LAMBDA} PS={10*LAMBDA+2*20*LAMBDA} AD={5*20*LAMBDA*LAMBDA} PD={10*LAMBDA+2*20*LAMBDA}
*     M2 out in low low CMOSN W={10*LAMBDA} L={2*LAMBDA}
*     + AS={5*10*LAMBDA*LAMBDA} PS={10*LAMBDA+2*10*LAMBDA} AD={5*10*LAMBDA*LAMBDA} PD={10*LAMBDA+2*10*LAMBDA}
* .ends InverterLoad

* vin in+ in- pulse VLow VHigh delay rise-time fall-time on-period time-period
VDD vdd gnd 'SUPPLY'
VClk clk_line gnd pulse gnd SUPPLY 0 1p 1p 10ns 20ns ; No Skew Currently, add a skew for practical measurements (3)
VA_not A0_not gnd pulse gnd SUPPLY 3n 1p 1p 20ns 40ns ; No Skew Currently, add a skew for practical measurements (4)
VB_not B0_not gnd pulse gnd SUPPLY 8n 1p 1p 30ns 60ns ; No Skew Currently, add a skew for practical measurements (5)
VCin_not Cin_not gnd pulse gnd SUPPLY 13n 1p 1p 70ns 140ns ; No Skew Currently, add a skew for practical measurements (6)

* VClk clk_line gnd pulse SUPPLY gnd 0 1p 1p 10ns 20ns
* VA_not A0_not gnd 0
* VB_not B0_not gnd 0
* VCin_not Cin_not gnd 'SUPPLY'

XC0_Bit_Logic clk_line A0_not B0_not Cin_not out vdd gnd C0_Bit_Logic

* Load
* XInverterL out temp vdd gnd InverterLoad

* .measure tran trise
* + TRIG V(out) VAL = 'SUPPLY / 10' TD = 5ns TO = 15ns RISE = 1
* + TARG V(out) VAL = '9 * SUPPLY / 10' TD = 5ns TO = 15ns RISE = 1

* .measure tran tfall
* + TRIG V(out) VAL = '9 * SUPPLY / 10' TD = 25ns TO = 35ns FALL = 1
* + TARG V(out) VAL = 'SUPPLY / 10' TD = 25ns TO = 35ns FALL = 1

* .measure tran delay param = '(trise + tfall) / 2'

* .measure tran tcqrise
* + TRIG V(clk_line) VAL = 'SUPPLY / 2' RISE = 1
* + TARG V(out) VAL = 'SUPPLY / 2' RISE = 1

* .measure tran tcqfall
* + TRIG V(clk_line) VAL = 'SUPPLY / 2' RISE = 2
* + TARG V(out) VAL = 'SUPPLY / 2' FALL = 1

* .measure tran tcq param = '(tcqrise + tcqfall) / 2'

.tran 10ps 160ns

.control

run
set hcopypscolor = 1
set color0 = white
set color1 = black
set curplottitle = "Siddarth Gottumukkula 2023102040"

let clock = 'clk_line + 8'
let in_a_bar = 'A0_not + 6'
let in_b_bar = 'B0_not + 4'
let in_cin_bar = 'Cin_not + 2'
let output = 'out'
plot clock in_a_bar in_b_bar in_cin_bar output

.endc

.end
