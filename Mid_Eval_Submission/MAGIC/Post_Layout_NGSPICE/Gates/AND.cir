* Extracted Netlist
.include TSMC_180nm.txt
.param SUPPLY=1.8
.global gnd vdd

* Supply
Vdd vdd gnd 'SUPPLY'

* SPICE3 file created from AND.ext - technology: scmos

.option scale=0.09u

M1000 a_13_43# AND_in_2 vdd w_0_37# CMOSP w=20 l=2
+  ad=160 pd=56 as=310 ps=154
M1001 a_13_4# AND_in_2 gnd Gnd CMOSN w=20 l=2
+  ad=160 pd=56 as=155 ps=82
M1002 a_13_43# AND_in_1 a_13_4# Gnd CMOSN w=20 l=2
+  ad=120 pd=52 as=0 ps=0
M1003 AND_out a_13_43# vdd w_0_37# CMOSP w=22 l=2
+  ad=110 pd=54 as=0 ps=0
M1004 vdd AND_in_1 a_13_43# w_0_37# CMOSP w=20 l=2
+  ad=0 pd=0 as=0 ps=0
M1005 AND_out a_13_43# gnd Gnd CMOSN w=11 l=2
+  ad=55 pd=32 as=0 ps=0
C0 w_0_37# vdd 0.09fF
C1 w_0_37# AND_in_1 0.06fF
C2 a_13_43# gnd 0.02fF
C3 AND_in_2 gnd 0.02fF
C4 w_0_37# AND_out 0.02fF
C5 AND_in_1 a_13_43# 0.02fF
C6 w_0_37# a_13_43# 0.22fF
C7 AND_in_2 AND_in_1 0.18fF
C8 w_0_37# AND_in_2 0.06fF
C9 a_13_43# AND_out 0.05fF
C10 AND_in_1 gnd 0.02fF
C11 gnd Gnd 0.01fF
C12 AND_out Gnd 0.03fF
C13 vdd Gnd 0.04fF
C14 a_13_43# Gnd 0.43fF
C15 AND_in_1 Gnd 0.17fF
C16 AND_in_2 Gnd 0.15fF
C17 w_0_37# Gnd 1.69fF

VD2 AND_in_1 gnd pulse 0 SUPPLY 0 50p 50p 1.25ns 2.5ns
VD1 AND_in_2 gnd pulse 0 SUPPLY 0 50p 50p 1ns 2ns

.tran 1ps 5ns

.control

run
set hcopypscolor = 1
set color0 = white
set color1 = black
set curplottitle = "Siddarth Gottumukkula 2023102040"
set xbrushwidth = 3

let in1 = 'AND_in_1 + 4'
let in2 = 'AND_in_2 + 2'
let output = 'AND_out'
plot in1 in2 output

.endc

.end
