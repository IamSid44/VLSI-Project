* Extracted Netlist
.include TSMC_180nm.txt
.param SUPPLY=1.8
.global gnd vdd

* Supply
Vdd vdd gnd 'SUPPLY'

* SPICE3 file created from NAND.ext - technology: scmos

.option scale=0.09u

M1000 NAND_Out NAND_In_2 vdd w_39_40# CMOSP w=20 l=2
+  ad=160 pd=56 as=200 ps=100
M1001 a_52_7# NAND_In_2 gnd Gnd CMOSN w=20 l=2
+  ad=160 pd=56 as=100 ps=50
M1002 NAND_Out NAND_In_1 a_52_7# Gnd CMOSN w=20 l=2
+  ad=120 pd=52 as=0 ps=0
M1003 vdd NAND_In_1 NAND_Out w_39_40# CMOSP w=20 l=2
+  ad=0 pd=0 as=0 ps=0
C0 NAND_In_1 NAND_In_2 0.18fF
C1 w_39_40# NAND_In_2 0.06fF
C2 NAND_In_1 NAND_Out 0.02fF
C3 NAND_In_1 w_39_40# 0.06fF
C4 vdd w_39_40# 0.06fF
C5 NAND_Out w_39_40# 0.15fF

VD2 NAND_in_1 gnd pulse 0 SUPPLY 0 50p 50p 1.25ns 2.5ns
VD1 NAND_in_2 gnd pulse 0 SUPPLY 0 50p 50p 1ns 2ns

.tran 1ps 5ns

.control

run
set hcopypscolor = 1
set color0 = white
set color1 = black
set curplottitle = "Siddarth Gottumukkula 2023102040"
set xbrushwidth = 3

let in1 = 'NAND_in_1 + 4'
let in2 = 'NAND_in_2 + 2'
let output = 'NAND_out'
plot in1 in2 output

.endc

.end
