* Extracted Netlist
.include TSMC_180nm.txt
.param SUPPLY=1.8
.global gnd vdd

* Supply
Vdd vdd gnd 'SUPPLY'

* SPICE3 file created from High_Latch.ext - technology: scmos

.option scale=0.09u

M1000 gnd high_latch_in a_39_6# Gnd CMOSN w=20 l=2
+  ad=200 pd=100 as=120 ps=52
M1001 High_Inter high_latch_in VDD w_1_n34# CMOSP w=20 l=2
+  ad=100 pd=50 as=200 ps=100
M1002 a_39_n28# clk high_latch_out Gnd CMOSN w=20 l=2
+  ad=120 pd=52 as=100 ps=50
M1003 gnd High_Inter a_39_n28# Gnd CMOSN w=20 l=2
+  ad=0 pd=0 as=0 ps=0
M1004 a_39_6# clk High_Inter Gnd CMOSN w=20 l=2
+  ad=0 pd=0 as=120 ps=52
M1005 high_latch_out High_Inter VDD w_1_n34# CMOSP w=20 l=2
+  ad=100 pd=50 as=0 ps=0
C0 high_latch_in w_1_n34# 0.08fF
C1 w_1_n34# High_Inter 0.15fF
C2 w_1_n34# high_latch_out 0.02fF
C3 high_latch_in VDD 0.05fF
C4 VDD High_Inter 0.04fF
C5 high_latch_in clk 0.16fF
C6 High_Inter clk 0.05fF
C7 high_latch_in High_Inter 0.02fF
C8 w_1_n34# VDD 0.12fF
C9 gnd High_Inter 0.05fF
C10 high_latch_out Gnd 0.03fF
C11 gnd Gnd 0.08fF
C12 High_Inter Gnd 0.43fF
C13 VDD Gnd 0.01fF
C14 clk Gnd 0.32fF
C15 high_latch_in Gnd 0.23fF
C16 w_1_n34# Gnd 1.59fF

VClk clk gnd pulse SUPPLY 0 0 50p 50p 0.5ns 1ns
VD high_latch_in gnd pulse 0 SUPPLY 0 50p 50p 0.75ns 1.5ns

.tran 1ps 5ns

.control

run
set hcopypscolor = 1
set color0 = white
set color1 = black
set curplottitle = "Siddarth Gottumukkula 2023102040"
set xbrushwidth = 3

let clock = 'clk + 4'
let input = 'high_latch_in + 2'
let output = 'high_latch_out'
plot clock input output

.endc

.end
