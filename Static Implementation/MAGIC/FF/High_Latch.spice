* SPICE3 file created from High_Latch.ext - technology: scmos

.option scale=0.09u

M1000 gnd in a_39_6# Gnd nfet w=20 l=2
+  ad=200 pd=100 as=120 ps=52
M1001 a_11_n5# in VDD w_1_n34# pfet w=20 l=2
+  ad=100 pd=50 as=200 ps=100
M1002 a_39_n28# clk out Gnd nfet w=20 l=2
+  ad=120 pd=52 as=100 ps=50
M1003 gnd a_11_n5# a_39_n28# Gnd nfet w=20 l=2
+  ad=0 pd=0 as=0 ps=0
M1004 a_39_6# clk a_11_n5# Gnd nfet w=20 l=2
+  ad=0 pd=0 as=120 ps=52
M1005 out a_11_n5# VDD w_1_n34# pfet w=20 l=2
+  ad=100 pd=50 as=0 ps=0
C0 a_11_n5# in 0.02fF
C1 VDD a_11_n5# 0.04fF
C2 VDD in 0.05fF
C3 a_11_n5# w_1_n34# 0.15fF
C4 w_1_n34# in 0.08fF
C5 clk a_11_n5# 0.05fF
C6 a_11_n5# gnd 0.05fF
C7 VDD w_1_n34# 0.12fF
C8 clk in 0.16fF
C9 w_1_n34# out 0.02fF
C10 out Gnd 0.03fF
C11 gnd Gnd 0.08fF
C12 a_11_n5# Gnd 0.42fF
C13 VDD Gnd 0.01fF
C14 clk Gnd 0.31fF
C15 in Gnd 0.21fF
C16 w_1_n34# Gnd 1.59fF
