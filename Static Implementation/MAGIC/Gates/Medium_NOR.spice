* SPICE3 file created from Medium_NOR.ext - technology: scmos

.option scale=0.09u

M1000 out_NOR in_2_NOR gnd Gnd nfet w=21 l=2
+  ad=168 pd=58 as=210 ps=104
M1001 a_13_6# in_2_NOR vdd w_0_0# pfet w=40 l=2
+  ad=320 pd=96 as=200 ps=90
M1002 out_NOR in_1_NOR a_13_6# w_0_0# pfet w=40 l=2
+  ad=200 pd=90 as=0 ps=0
M1003 gnd in_1_NOR out_NOR Gnd nfet w=21 l=2
+  ad=0 pd=0 as=0 ps=0
C0 in_2_NOR gnd 0.02fF
C1 vdd w_0_0# 0.02fF
C2 w_0_0# out_NOR 0.02fF
C3 in_1_NOR out_NOR 0.19fF
C4 in_2_NOR out_NOR 0.03fF
C5 w_0_0# in_1_NOR 0.06fF
C6 w_0_0# in_2_NOR 0.06fF
C7 in_2_NOR in_1_NOR 0.16fF
C8 in_1_NOR gnd 0.02fF
C9 gnd Gnd 0.06fF
C10 out_NOR Gnd 0.06fF
C11 vdd Gnd 0.01fF
C12 in_1_NOR Gnd 0.19fF
C13 in_2_NOR Gnd 0.17fF
C14 w_0_0# Gnd 1.78fF
