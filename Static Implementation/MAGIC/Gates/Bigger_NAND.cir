* Extracted Netlist
.include TSMC_180nm.txt
.param SUPPLY=1.8
.global gnd vdd

* Supply
Vdd vdd gnd 'SUPPLY'

* SPICE3 file created from Bigger_NAND.ext - technology: scmos

.option scale=0.09u

M1000 NAND_Out NAND_In_2 vdd w_46_37# CMOSP w=40 l=2
+  ad=320 pd=96 as=400 ps=180
M1001 NAND_Out NAND_In_1 a_59_n16# Gnd CMOSN w=40 l=2
+  ad=240 pd=92 as=320 ps=96
M1002 a_59_n16# NAND_In_2 gnd Gnd CMOSN w=40 l=2
+  ad=0 pd=0 as=200 ps=90
M1003 vdd NAND_In_1 NAND_Out w_46_37# CMOSP w=40 l=2
+  ad=0 pd=0 as=0 ps=0
C0 NAND_In_1 w_46_37# 0.06fF
C1 NAND_In_1 NAND_Out 0.02fF
C2 NAND_In_2 NAND_In_1 0.18fF
C3 NAND_Out w_46_37# 0.15fF
C4 NAND_In_2 w_46_37# 0.06fF
C5 vdd w_46_37# 0.06fF
C6 gnd Gnd 0.01fF
C7 NAND_Out Gnd 0.19fF
C8 vdd Gnd 0.04fF
C9 NAND_In_1 Gnd 0.16fF
C10 NAND_In_2 Gnd 0.14fF
C11 w_46_37# Gnd 1.78fF

VD2 NAND_in_1 gnd pulse 0 SUPPLY 0 50p 50p 1.25ns 2.5ns
VD1 NAND_in_2 gnd pulse 0 SUPPLY 0 50p 50p 1ns 2ns

.tran 1ps 5ns

.control

run
set hcopypscolor = 1
set color0 = white
set color1 = black
set curplottitle = "Siddarth Gottumukkula 2023102040"
set xbrushwidth = 3

let in1 = 'NAND_in_1 + 4'
let in2 = 'NAND_in_2 + 2'
let output = 'NAND_out'
plot in1 in2 output

.endc

.end
