* SPICE3 file created from Small_NOR.ext - technology: scmos

.option scale=0.09u

M1000 out_NOR in_1_NOR a_n26_48# w_n39_42# pfet w=10 l=2
+  ad=50 pd=30 as=80 ps=36
M1001 out_NOR in_2_NOR gnd Gnd nfet w=5 l=2
+  ad=40 pd=26 as=50 ps=40
M1002 gnd in_1_NOR out_NOR Gnd nfet w=5 l=2
+  ad=0 pd=0 as=0 ps=0
M1003 a_n26_48# in_2_NOR vdd w_n39_42# pfet w=10 l=2
+  ad=0 pd=0 as=50 ps=30
C0 vdd w_n39_42# 0.02fF
C1 gnd in_1_NOR 0.02fF
C2 w_n39_42# in_1_NOR 0.06fF
C3 out_NOR gnd 0.11fF
C4 out_NOR w_n39_42# 0.02fF
C5 out_NOR in_1_NOR 0.19fF
C6 in_2_NOR gnd 0.08fF
C7 in_2_NOR w_n39_42# 0.06fF
C8 in_2_NOR in_1_NOR 0.18fF
C9 out_NOR in_2_NOR 0.03fF
C10 gnd Gnd 0.06fF
C11 out_NOR Gnd 0.06fF
C12 vdd Gnd 0.01fF
C13 in_1_NOR Gnd 0.19fF
C14 in_2_NOR Gnd 0.17fF
C15 w_n39_42# Gnd 0.75fF
