* SPICE3 file created from CLA_Final.ext - technology: scmos

.option scale=0.09u

M1000 gnd B2 P2_Not Gnd nfet w=40 l=2
+  ad=5041 pd=2524 as=320 ps=96
M1001 vdd Cin a_173_n86# w_160_n92# pfet w=20 l=2
+  ad=7210 pd=3338 as=160 ps=56
M1002 C0_Inter_01 a_39_96# vdd w_26_129# pfet w=22 l=2
+  ad=110 pd=54 as=0 ps=0
M1003 Inter_S3 B3 A3 w_n160_n577# pfet w=10 l=2
+  ad=60 pd=32 as=50 ps=30
M1004 G3_Not A3 a_n147_n515# Gnd nfet w=40 l=2
+  ad=240 pd=92 as=320 ps=96
M1005 C2_Inter_01 a_134_n213# vdd w_121_n219# pfet w=22 l=2
+  ad=110 pd=54 as=0 ps=0
M1006 a_88_n314# a_46_n316# gnd Gnd nfet w=20 l=2
+  ad=160 pd=56 as=0 ps=0
M1007 Inter_S3 B3 a_n147_n571# Gnd nfet w=5 l=2
+  ad=30 pd=22 as=90 ps=56
M1008 gnd P1_Not a_24_n104# Gnd nfet w=20 l=2
+  ad=0 pd=0 as=160 ps=56
M1009 C1_Inter_NAND G1_Not a_90_n34# Gnd nfet w=20 l=2
+  ad=120 pd=52 as=160 ps=56
M1010 a_46_n316# a_22_n384# vdd w_9_n351# pfet w=22 l=2
+  ad=110 pd=54 as=0 ps=0
M1011 C1 a_248_n65# vdd w_235_n32# pfet w=22 l=2
+  ad=110 pd=54 as=0 ps=0
M1012 a_7_127# Cin gnd Gnd nfet w=11 l=2
+  ad=55 pd=32 as=0 ps=0
M1013 C3_Inter_NOR P3_Not gnd Gnd nfet w=5 l=2
+  ad=40 pd=26 as=0 ps=0
M1014 gnd P0_Not C1_Inter_NOR Gnd nfet w=5 l=2
+  ad=0 pd=0 as=40 ps=26
M1015 B0 A0 Inter_S0 w_n162_12# pfet w=10 l=2
+  ad=60 pd=32 as=60 ps=32
M1016 a_24_n104# P1_Not a_24_n65# w_11_n71# pfet w=40 l=2
+  ad=200 pd=90 as=320 ps=96
M1017 G0_Not B0 vdd w_n162_127# pfet w=40 l=2
+  ad=320 pd=96 as=0 ps=0
M1018 Inter_S0 B0 a_n149_18# Gnd nfet w=5 l=2
+  ad=30 pd=22 as=90 ps=56
M1019 gnd P3_Not a_22_n384# Gnd nfet w=20 l=2
+  ad=0 pd=0 as=160 ps=56
M1020 C2_Inter_NOR P1_Not a_73_n249# w_67_n263# pfet w=10 l=2
+  ad=50 pd=30 as=80 ps=36
M1021 a_46_n176# a_22_n244# gnd Gnd nfet w=11 l=2
+  ad=55 pd=32 as=0 ps=0
M1022 P1_Not A1 gnd Gnd nfet w=40 l=2
+  ad=320 pd=96 as=0 ps=0
M1023 a_223_n237# C2_Inter_01 gnd Gnd nfet w=20 l=2
+  ad=160 pd=56 as=0 ps=0
M1024 P2_Not B2 a_n96_n288# w_n109_n294# pfet w=80 l=2
+  ad=400 pd=170 as=640 ps=176
M1025 vdd A3 G3_Not w_n160_n462# pfet w=40 l=2
+  ad=0 pd=0 as=320 ps=96
M1026 a_22_n205# G1_Not vdd w_9_n211# pfet w=40 l=2
+  ad=320 pd=96 as=0 ps=0
M1027 a_134_n213# C2_Inter_NOR vdd w_121_n219# pfet w=20 l=2
+  ad=160 pd=56 as=0 ps=0
M1028 a_248_n65# C1_Inter_NAND a_248_n26# w_235_n32# pfet w=40 l=2
+  ad=200 pd=90 as=320 ps=96
M1029 Inter_S2 B2 A2 w_n161_n369# pfet w=10 l=2
+  ad=60 pd=32 as=50 ps=30
M1030 P0_Not A0 gnd Gnd nfet w=40 l=2
+  ad=320 pd=96 as=0 ps=0
M1031 a_n148_n307# B2 gnd Gnd nfet w=40 l=2
+  ad=320 pd=96 as=0 ps=0
M1032 Inter_S2 B2 a_n148_n363# Gnd nfet w=5 l=2
+  ad=30 pd=22 as=90 ps=56
M1033 a_88_n174# a_46_n176# gnd Gnd nfet w=20 l=2
+  ad=160 pd=56 as=0 ps=0
M1034 a_39_135# P0_Not vdd w_26_129# pfet w=40 l=2
+  ad=320 pd=96 as=0 ps=0
M1035 a_24_n104# G0_Not gnd Gnd nfet w=20 l=2
+  ad=0 pd=0 as=0 ps=0
M1036 P3_Not A3 gnd Gnd nfet w=40 l=2
+  ad=320 pd=96 as=0 ps=0
M1037 a_n148_n363# A2 vdd w_n161_n369# pfet w=22 l=2
+  ad=110 pd=54 as=0 ps=0
M1038 C1_Inter_01 a_173_n86# vdd w_160_n92# pfet w=22 l=2
+  ad=110 pd=54 as=0 ps=0
M1039 a_n148_n363# A2 gnd Gnd nfet w=11 l=2
+  ad=0 pd=0 as=0 ps=0
M1040 gnd B1 P1_Not Gnd nfet w=40 l=2
+  ad=0 pd=0 as=0 ps=0
M1041 a_173_n86# C1_Inter_NOR vdd w_160_n92# pfet w=20 l=2
+  ad=0 pd=0 as=0 ps=0
M1042 a_46_n176# a_22_n244# vdd w_9_n211# pfet w=22 l=2
+  ad=110 pd=54 as=0 ps=0
M1043 a_n99_n99# A1 vdd w_n112_n105# pfet w=80 l=2
+  ad=640 pd=176 as=0 ps=0
M1044 a_22_n384# G2_Not gnd Gnd nfet w=20 l=2
+  ad=0 pd=0 as=0 ps=0
M1045 C2_Inter_NOR P2_Not gnd Gnd nfet w=5 l=2
+  ad=40 pd=26 as=0 ps=0
M1046 gnd a_7_127# a_39_96# Gnd nfet w=20 l=2
+  ad=0 pd=0 as=160 ps=56
M1047 C3_Inter_NAND G3_Not a_88_n314# Gnd nfet w=20 l=2
+  ad=120 pd=52 as=0 ps=0
M1048 C1_Inter_NAND a_48_n36# vdd w_11_n71# pfet w=20 l=2
+  ad=160 pd=56 as=0 ps=0
M1049 a_134_n213# C0 a_134_n252# Gnd nfet w=20 l=2
+  ad=120 pd=52 as=160 ps=56
M1050 gnd P2_Not a_22_n244# Gnd nfet w=20 l=2
+  ad=0 pd=0 as=160 ps=56
M1051 gnd P2_Not C3_Inter_NOR Gnd nfet w=5 l=2
+  ad=0 pd=0 as=0 ps=0
M1052 vdd A0 G0_Not w_n162_127# pfet w=40 l=2
+  ad=0 pd=0 as=0 ps=0
M1053 a_n97_93# A0 vdd w_n110_87# pfet w=80 l=2
+  ad=640 pd=176 as=0 ps=0
M1054 a_24_n65# G0_Not vdd w_11_n71# pfet w=40 l=2
+  ad=0 pd=0 as=0 ps=0
M1055 C3_Inter_NAND a_46_n316# vdd w_9_n351# pfet w=20 l=2
+  ad=160 pd=56 as=0 ps=0
M1056 a_n149_18# A0 gnd Gnd nfet w=11 l=2
+  ad=0 pd=0 as=0 ps=0
M1057 C2 a_223_n237# gnd Gnd nfet w=11 l=2
+  ad=55 pd=32 as=0 ps=0
M1058 vdd C0_Inter_01 C0 w_31_49# pfet w=20 l=2
+  ad=0 pd=0 as=160 ps=56
M1059 B3 A3 Inter_S3 w_n160_n577# pfet w=10 l=2
+  ad=60 pd=32 as=0 ps=0
M1060 G2_Not B2 vdd w_n161_n254# pfet w=40 l=2
+  ad=320 pd=96 as=0 ps=0
M1061 a_48_n36# a_24_n104# gnd Gnd nfet w=11 l=2
+  ad=55 pd=32 as=0 ps=0
M1062 B3 a_n147_n571# Inter_S3 Gnd nfet w=5 l=2
+  ad=30 pd=22 as=0 ps=0
M1063 B1 A1 Inter_S1 w_n164_n180# pfet w=10 l=2
+  ad=60 pd=32 as=60 ps=32
M1064 B1 a_n151_n174# Inter_S1 Gnd nfet w=5 l=2
+  ad=30 pd=22 as=30 ps=22
M1065 a_75_n109# P1_Not vdd w_69_n123# pfet w=10 l=2
+  ad=80 pd=36 as=0 ps=0
M1066 a_223_n237# C2_Inter_NAND a_223_n198# w_210_n204# pfet w=40 l=2
+  ad=200 pd=90 as=320 ps=96
M1067 Inter_S0 B0 A0 w_n162_12# pfet w=10 l=2
+  ad=0 pd=0 as=50 ps=30
M1068 a_n95_n496# A3 vdd w_n108_n502# pfet w=80 l=2
+  ad=640 pd=176 as=0 ps=0
M1069 a_n149_74# B0 gnd Gnd nfet w=40 l=2
+  ad=320 pd=96 as=0 ps=0
M1070 G2_Not A2 a_n148_n307# Gnd nfet w=40 l=2
+  ad=240 pd=92 as=0 ps=0
M1071 gnd B0 P0_Not Gnd nfet w=40 l=2
+  ad=0 pd=0 as=0 ps=0
M1072 C2_Inter_01 a_134_n213# gnd Gnd nfet w=11 l=2
+  ad=55 pd=32 as=0 ps=0
M1073 a_73_n389# P3_Not vdd w_67_n403# pfet w=10 l=2
+  ad=80 pd=36 as=0 ps=0
M1074 a_248_n26# C1_Inter_01 vdd w_235_n32# pfet w=40 l=2
+  ad=0 pd=0 as=0 ps=0
M1075 gnd B3 P3_Not Gnd nfet w=40 l=2
+  ad=0 pd=0 as=0 ps=0
M1076 a_n151_n118# B1 gnd Gnd nfet w=40 l=2
+  ad=320 pd=96 as=0 ps=0
M1077 G1_Not B1 vdd w_n164_n65# pfet w=40 l=2
+  ad=320 pd=96 as=0 ps=0
M1078 C2_Inter_NAND G2_Not a_88_n174# Gnd nfet w=20 l=2
+  ad=120 pd=52 as=0 ps=0
M1079 C1 a_248_n65# gnd Gnd nfet w=11 l=2
+  ad=55 pd=32 as=0 ps=0
M1080 a_39_96# P0_Not gnd Gnd nfet w=20 l=2
+  ad=0 pd=0 as=0 ps=0
M1081 C2_Inter_NAND a_46_n176# vdd w_9_n211# pfet w=20 l=2
+  ad=160 pd=56 as=0 ps=0
M1082 a_n151_n174# A1 vdd w_n164_n180# pfet w=22 l=2
+  ad=110 pd=54 as=0 ps=0
M1083 a_22_n244# G1_Not gnd Gnd nfet w=20 l=2
+  ad=0 pd=0 as=0 ps=0
M1084 a_134_n252# C2_Inter_NOR gnd Gnd nfet w=20 l=2
+  ad=0 pd=0 as=0 ps=0
M1085 a_n151_n174# A1 gnd Gnd nfet w=11 l=2
+  ad=90 pd=56 as=0 ps=0
M1086 P0_Not B0 a_n97_93# w_n110_87# pfet w=80 l=2
+  ad=400 pd=170 as=0 ps=0
M1087 C1_Inter_01 a_173_n86# gnd Gnd nfet w=11 l=2
+  ad=55 pd=32 as=0 ps=0
M1088 gnd C1_Inter_NAND a_248_n65# Gnd nfet w=20 l=2
+  ad=0 pd=0 as=160 ps=56
M1089 a_48_n36# a_24_n104# vdd w_11_n71# pfet w=22 l=2
+  ad=110 pd=54 as=0 ps=0
M1090 gnd P1_Not C2_Inter_NOR Gnd nfet w=5 l=2
+  ad=0 pd=0 as=0 ps=0
M1091 vdd A2 G2_Not w_n161_n254# pfet w=40 l=2
+  ad=0 pd=0 as=0 ps=0
M1092 C0 C0_Inter_01 a_44_16# Gnd nfet w=20 l=2
+  ad=120 pd=52 as=160 ps=56
M1093 vdd G1_Not C1_Inter_NAND w_11_n71# pfet w=20 l=2
+  ad=0 pd=0 as=0 ps=0
M1094 C0 G0_Not vdd w_31_49# pfet w=20 l=2
+  ad=0 pd=0 as=0 ps=0
M1095 vdd G3_Not C3_Inter_NAND w_9_n351# pfet w=20 l=2
+  ad=0 pd=0 as=0 ps=0
M1096 B0 a_n149_18# Inter_S0 Gnd nfet w=5 l=2
+  ad=30 pd=22 as=0 ps=0
M1097 a_22_n384# P3_Not a_22_n345# w_9_n351# pfet w=40 l=2
+  ad=200 pd=90 as=320 ps=96
M1098 a_223_n198# C2_Inter_01 vdd w_210_n204# pfet w=40 l=2
+  ad=0 pd=0 as=0 ps=0
M1099 P1_Not B1 a_n99_n99# w_n112_n105# pfet w=80 l=2
+  ad=400 pd=170 as=0 ps=0
M1100 P3_Not B3 a_n95_n496# w_n108_n502# pfet w=80 l=2
+  ad=400 pd=170 as=0 ps=0
M1101 G0_Not A0 a_n149_74# Gnd nfet w=40 l=2
+  ad=240 pd=92 as=0 ps=0
M1102 a_90_n34# a_48_n36# gnd Gnd nfet w=20 l=2
+  ad=0 pd=0 as=0 ps=0
M1103 a_173_n86# Cin a_173_n125# Gnd nfet w=20 l=2
+  ad=120 pd=52 as=160 ps=56
M1104 C1_Inter_NOR P1_Not gnd Gnd nfet w=5 l=2
+  ad=0 pd=0 as=0 ps=0
M1105 P2_Not A2 gnd Gnd nfet w=40 l=2
+  ad=0 pd=0 as=0 ps=0
M1106 C1_Inter_NOR P0_Not a_75_n109# w_69_n123# pfet w=10 l=2
+  ad=50 pd=30 as=0 ps=0
M1107 a_n147_n515# B3 gnd Gnd nfet w=40 l=2
+  ad=0 pd=0 as=0 ps=0
M1108 a_n149_18# A0 vdd w_n162_12# pfet w=22 l=2
+  ad=110 pd=54 as=0 ps=0
M1109 G1_Not A1 a_n151_n118# Gnd nfet w=40 l=2
+  ad=240 pd=92 as=0 ps=0
M1110 a_73_n249# P2_Not vdd w_67_n263# pfet w=10 l=2
+  ad=0 pd=0 as=0 ps=0
M1111 Inter_S1 B1 A1 w_n164_n180# pfet w=10 l=2
+  ad=0 pd=0 as=50 ps=30
M1112 C2 a_223_n237# vdd w_210_n204# pfet w=22 l=2
+  ad=110 pd=54 as=0 ps=0
M1113 Inter_S1 B1 a_n151_n174# Gnd nfet w=5 l=2
+  ad=0 pd=0 as=0 ps=0
M1114 a_n147_n571# A3 vdd w_n160_n577# pfet w=22 l=2
+  ad=110 pd=54 as=0 ps=0
M1115 C3_Inter_NOR P2_Not a_73_n389# w_67_n403# pfet w=10 l=2
+  ad=50 pd=30 as=0 ps=0
M1116 a_46_n316# a_22_n384# gnd Gnd nfet w=11 l=2
+  ad=55 pd=32 as=0 ps=0
M1117 a_n147_n571# A3 gnd Gnd nfet w=11 l=2
+  ad=0 pd=0 as=0 ps=0
M1118 vdd A1 G1_Not w_n164_n65# pfet w=40 l=2
+  ad=0 pd=0 as=0 ps=0
M1119 C0_Inter_01 a_39_96# gnd Gnd nfet w=11 l=2
+  ad=55 pd=32 as=0 ps=0
M1120 B2 A2 Inter_S2 w_n161_n369# pfet w=10 l=2
+  ad=60 pd=32 as=0 ps=0
M1121 B2 a_n148_n363# Inter_S2 Gnd nfet w=5 l=2
+  ad=30 pd=22 as=0 ps=0
M1122 gnd C2_Inter_NAND a_223_n237# Gnd nfet w=20 l=2
+  ad=0 pd=0 as=0 ps=0
M1123 vdd G2_Not C2_Inter_NAND w_9_n211# pfet w=20 l=2
+  ad=0 pd=0 as=0 ps=0
M1124 a_44_16# G0_Not gnd Gnd nfet w=20 l=2
+  ad=0 pd=0 as=0 ps=0
M1125 a_248_n65# C1_Inter_01 gnd Gnd nfet w=20 l=2
+  ad=0 pd=0 as=0 ps=0
M1126 a_n96_n288# A2 vdd w_n109_n294# pfet w=80 l=2
+  ad=0 pd=0 as=0 ps=0
M1127 G3_Not B3 vdd w_n160_n462# pfet w=40 l=2
+  ad=0 pd=0 as=0 ps=0
M1128 a_22_n345# G2_Not vdd w_9_n351# pfet w=40 l=2
+  ad=0 pd=0 as=0 ps=0
M1129 a_7_127# Cin vdd w_n6_144# pfet w=22 l=2
+  ad=110 pd=54 as=0 ps=0
M1130 a_22_n244# P2_Not a_22_n205# w_9_n211# pfet w=40 l=2
+  ad=200 pd=90 as=0 ps=0
M1131 a_39_96# a_7_127# a_39_135# w_26_129# pfet w=40 l=2
+  ad=200 pd=90 as=0 ps=0
M1132 vdd C0 a_134_n213# w_121_n219# pfet w=20 l=2
+  ad=0 pd=0 as=0 ps=0
M1133 a_173_n125# C1_Inter_NOR gnd Gnd nfet w=20 l=2
+  ad=0 pd=0 as=0 ps=0
C0 P0_Not G0_Not 0.68fF
C1 A0 gnd 0.26fF
C2 B0 Inter_S0 0.35fF
C3 A0 a_n149_18# 0.16fF
C4 a_7_127# a_39_96# 0.19fF
C5 w_235_n32# a_248_n65# 0.09fF
C6 w_n161_n254# B2 0.06fF
C7 Cin C0_Inter_01 0.58fF
C8 gnd C0 1.17fF
C9 P2_Not a_22_n384# 0.02fF
C10 P1_Not a_22_n205# 0.01fF
C11 w_n160_n462# B3 0.06fF
C12 w_n164_n180# vdd 0.02fF
C13 w_11_n71# P1_Not 0.06fF
C14 C1_Inter_01 C1_Inter_NAND 0.22fF
C15 gnd G1_Not 0.14fF
C16 w_9_n351# P2_Not 0.17fF
C17 w_n161_n369# B2 0.40fF
C18 P0_Not P1_Not 0.03fF
C19 vdd C3_Inter_NOR 0.13fF
C20 B1 G1_Not 0.29fF
C21 C3_Inter_NAND G3_Not 0.03fF
C22 w_160_n92# C1_Inter_01 0.02fF
C23 C2_Inter_NAND a_46_n176# 0.09fF
C24 C0 C1_Inter_NOR 0.05fF
C25 gnd a_173_n86# 0.02fF
C26 P2_Not G2_Not 0.15fF
C27 G1_Not a_24_n65# 0.01fF
C28 G2_Not A2 0.27fF
C29 w_n160_n462# vdd 0.09fF
C30 gnd C2_Inter_NAND 0.09fF
C31 w_n6_144# vdd 0.02fF
C32 w_n162_12# A0 0.26fF
C33 w_26_129# a_7_127# 0.07fF
C34 C2_Inter_01 a_134_n213# 0.05fF
C35 a_248_n65# C1 0.04fF
C36 vdd P2_Not 0.08fF
C37 gnd a_46_n176# 0.95fF
C38 w_69_n123# P0_Not 0.06fF
C39 G3_Not A3 0.27fF
C40 w_n164_n65# B1 0.06fF
C41 w_210_n204# C2_Inter_NAND 0.06fF
C42 B0 G0_Not 0.49fF
C43 P0_Not a_7_127# 0.25fF
C44 G1_Not G2_Not 0.06fF
C45 a_7_127# Cin 0.04fF
C46 w_n112_n105# P1_Not 0.02fF
C47 vdd C0 0.04fF
C48 gnd a_n149_18# 0.07fF
C49 gnd P3_Not 0.38fF
C50 a_223_n237# C2 0.04fF
C51 C0 C1_Inter_NAND 0.05fF
C52 vdd G1_Not 0.22fF
C53 gnd B1 0.06fF
C54 C1_Inter_NAND G1_Not 0.03fF
C55 w_n160_n577# A3 0.26fF
C56 G0_Not a_24_n104# 0.02fF
C57 gnd C1_Inter_NOR 0.47fF
C58 P3_Not a_22_n384# 0.20fF
C59 C2_Inter_NAND G2_Not 0.03fF
C60 C1_Inter_01 a_248_n65# 0.03fF
C61 gnd B3 0.06fF
C62 G1_Not a_n99_n99# 0.01fF
C63 A1 P1_Not 0.03fF
C64 P3_Not B3 0.19fF
C65 w_121_n219# C0 0.06fF
C66 G2_Not a_46_n176# 0.24fF
C67 G1_Not a_48_n36# 0.24fF
C68 w_9_n351# P3_Not 0.06fF
C69 vdd C2_Inter_NAND 0.13fF
C70 w_n162_127# vdd 0.09fF
C71 a_22_n345# G3_Not 0.01fF
C72 P1_Not a_24_n104# 0.20fF
C73 w_n164_n65# vdd 0.09fF
C74 w_n6_144# Cin 0.06fF
C75 gnd Inter_S3 0.12fF
C76 w_n162_12# a_n149_18# 0.02fF
C77 vdd a_46_n176# 0.12fF
C78 gnd G2_Not 0.14fF
C79 w_9_n351# a_22_n384# 0.09fF
C80 w_160_n92# a_173_n86# 0.22fF
C81 G2_Not P3_Not 0.20fF
C82 A0 P0_Not 0.03fF
C83 w_67_n403# C3_Inter_NOR 0.06fF
C84 vdd gnd 0.85fF
C85 A2 a_n148_n363# 0.16fF
C86 w_11_n71# G1_Not 0.09fF
C87 G0_Not C0_Inter_01 0.32fF
C88 vdd P3_Not 0.00fF
C89 w_235_n32# C1 0.02fF
C90 Cin C0 0.27fF
C91 gnd C1_Inter_NAND 0.15fF
C92 G2_Not a_22_n384# 0.02fF
C93 P2_Not a_46_n316# 0.07fF
C94 w_n109_n294# P2_Not 0.02fF
C95 B3 Inter_S3 0.35fF
C96 w_n109_n294# A2 0.06fF
C97 P0_Not G1_Not 0.05fF
C98 w_n108_n502# A3 0.06fF
C99 w_210_n204# vdd 0.12fF
C100 P1_Not C2_Inter_NOR 0.26fF
C101 w_9_n351# G2_Not 0.06fF
C102 gnd Inter_S2 0.12fF
C103 G0_Not P1_Not 0.10fF
C104 w_n164_n180# A1 0.26fF
C105 vdd C1_Inter_NOR 0.13fF
C106 gnd a_48_n36# 0.95fF
C107 w_67_n403# P2_Not 0.06fF
C108 w_67_n263# C2_Inter_NOR 0.06fF
C109 w_9_n351# vdd 0.23fF
C110 Cin a_173_n86# 0.02fF
C111 P2_Not B2 0.19fF
C112 w_9_n211# P1_Not 0.17fF
C113 B2 A2 1.61fF
C114 gnd a_n147_n571# 0.07fF
C115 w_n110_87# A0 0.06fF
C116 w_n162_12# vdd 0.02fF
C117 w_31_49# G0_Not 0.06fF
C118 C2_Inter_NAND a_223_n237# 0.19fF
C119 A1 a_n151_n174# 0.16fF
C120 w_31_49# C0_Inter_01 0.06fF
C121 w_160_n92# C1_Inter_NOR 0.06fF
C122 vdd G2_Not 0.15fF
C123 w_235_n32# C1_Inter_01 0.06fF
C124 w_67_n263# P1_Not 0.06fF
C125 w_n112_n105# G1_Not 0.01fF
C126 B0 A0 1.61fF
C127 w_n160_n462# G3_Not 0.15fF
C128 P0_Not gnd 0.17fF
C129 w_9_n211# a_22_n244# 0.09fF
C130 gnd Cin 0.06fF
C131 vdd a_73_n249# 0.01fF
C132 B3 a_n147_n571# 0.17fF
C133 w_n161_n254# A2 0.06fF
C134 vdd C1_Inter_NAND 0.06fF
C135 P2_Not G3_Not 0.15fF
C136 C0 a_134_n213# 0.02fF
C137 P1_Not a_22_n244# 0.02fF
C138 w_n160_n462# A3 0.06fF
C139 w_69_n123# P1_Not 0.06fF
C140 gnd a_n148_n363# 0.07fF
C141 w_n161_n369# A2 0.26fF
C142 w_210_n204# a_223_n237# 0.09fF
C143 P0_Not a_24_n65# 0.01fF
C144 a_n147_n571# Inter_S3 0.05fF
C145 w_160_n92# vdd 0.09fF
C146 gnd a_46_n316# 0.95fF
C147 vdd a_48_n36# 0.12fF
C148 P0_Not C1_Inter_NOR 0.26fF
C149 Cin C1_Inter_NOR 0.31fF
C150 A1 G1_Not 0.27fF
C151 C1_Inter_NAND a_48_n36# 0.09fF
C152 w_121_n219# vdd 0.09fF
C153 a_22_n205# G2_Not 0.01fF
C154 G1_Not a_24_n104# 0.01fF
C155 w_n162_127# B0 0.06fF
C156 a_22_n384# a_46_n316# 0.05fF
C157 w_26_129# vdd 0.11fF
C158 P2_Not C2_Inter_NOR 0.02fF
C159 w_67_n403# P3_Not 0.06fF
C160 w_26_129# a_39_96# 0.09fF
C161 w_n164_n180# Inter_S1 0.03fF
C162 gnd B2 0.06fF
C163 w_11_n71# vdd 0.23fF
C164 w_9_n351# a_46_n316# 0.10fF
C165 w_11_n71# C1_Inter_NAND 0.15fF
C166 w_n112_n105# B1 0.06fF
C167 w_n164_n65# A1 0.06fF
C168 P0_Not vdd 0.16fF
C169 B0 gnd 0.06fF
C170 A0 G0_Not 0.50fF
C171 C0 C2_Inter_NOR 0.26fF
C172 w_9_n211# P2_Not 0.06fF
C173 P0_Not a_39_96# 0.03fF
C174 vdd Cin 0.06fF
C175 B0 a_n149_18# 0.17fF
C176 gnd a_134_n213# 0.02fF
C177 gnd Inter_S0 0.12fF
C178 P2_Not a_22_n345# 0.01fF
C179 gnd C3_Inter_NAND 0.06fF
C180 P1_Not P2_Not 0.03fF
C181 Cin C1_Inter_NAND 0.05fF
C182 a_n149_18# Inter_S0 0.05fF
C183 C0_Inter_01 C0 0.02fF
C184 a_n151_n174# Inter_S1 0.05fF
C185 w_11_n71# a_48_n36# 0.10fF
C186 gnd A1 0.26fF
C187 G0_Not G1_Not 0.06fF
C188 w_67_n263# P2_Not 0.06fF
C189 C2_Inter_01 C2_Inter_NAND 0.36fF
C190 gnd G3_Not 0.12fF
C191 vdd a_46_n316# 0.12fF
C192 P0_Not a_48_n36# 0.07fF
C193 w_n109_n294# vdd 0.02fF
C194 w_160_n92# Cin 0.06fF
C195 B1 A1 1.61fF
C196 P3_Not G3_Not 0.00fF
C197 C1_Inter_NAND a_248_n65# 0.19fF
C198 w_9_n211# G1_Not 0.06fF
C199 gnd A3 0.26fF
C200 vdd a_75_n109# 0.01fF
C201 a_n148_n363# Inter_S2 0.05fF
C202 P2_Not a_22_n244# 0.20fF
C203 G1_Not P1_Not 0.06fF
C204 P3_Not A3 0.03fF
C205 G2_Not B2 0.26fF
C206 w_9_n351# C3_Inter_NAND 0.15fF
C207 w_67_n403# vdd 0.19fF
C208 gnd C2_Inter_01 0.02fF
C209 w_n162_127# G0_Not 0.15fF
C210 w_n6_144# a_7_127# 0.02fF
C211 w_n110_87# vdd 0.02fF
C212 w_n162_12# B0 0.40fF
C213 w_26_129# P0_Not 0.06fF
C214 a_22_n384# G3_Not 0.01fF
C215 w_n164_n180# a_n151_n174# 0.02fF
C216 w_n112_n105# vdd 0.02fF
C217 w_31_49# C0 0.15fF
C218 w_n162_12# Inter_S0 0.03fF
C219 w_11_n71# P0_Not 0.17fF
C220 G3_Not B3 0.26fF
C221 w_9_n351# G3_Not 0.09fF
C222 w_9_n211# C2_Inter_NAND 0.15fF
C223 w_210_n204# C2_Inter_01 0.06fF
C224 gnd C2_Inter_NOR 0.40fF
C225 B3 A3 1.61fF
C226 G1_Not a_22_n244# 0.02fF
C227 P0_Not Cin 0.05fF
C228 G0_Not gnd 0.02fF
C229 w_n161_n254# G2_Not 0.15fF
C230 w_9_n211# a_46_n176# 0.10fF
C231 gnd C0_Inter_01 0.06fF
C232 B2 Inter_S2 0.35fF
C233 P2_Not C3_Inter_NOR 0.26fF
C234 G2_Not G3_Not 0.05fF
C235 P1_Not a_46_n176# 0.07fF
C236 w_n161_n254# vdd 0.09fF
C237 vdd G3_Not 0.19fF
C238 w_n160_n577# B3 0.40fF
C239 gnd P1_Not 0.47fF
C240 w_n161_n369# vdd 0.02fF
C241 B1 P1_Not 0.19fF
C242 w_121_n219# a_134_n213# 0.22fF
C243 P2_Not A2 0.03fF
C244 a_22_n244# a_46_n176# 0.05fF
C245 w_n160_n577# Inter_S3 0.03fF
C246 C1_Inter_01 a_173_n86# 0.05fF
C247 gnd Inter_S1 0.12fF
C248 w_n110_87# P0_Not 0.02fF
C249 w_235_n32# vdd 0.12fF
C250 P1_Not C1_Inter_NOR 0.02fF
C251 a_24_n104# a_48_n36# 0.05fF
C252 w_235_n32# C1_Inter_NAND 0.06fF
C253 B1 Inter_S1 0.35fF
C254 w_n108_n502# P3_Not 0.02fF
C255 w_n161_n369# Inter_S2 0.03fF
C256 w_n160_n577# vdd 0.02fF
C257 vdd C2_Inter_NOR 0.13fF
C258 B0 P0_Not 0.19fF
C259 G1_Not P2_Not 0.32fF
C260 vdd G0_Not 0.10fF
C261 a_7_127# gnd 0.02fF
C262 B2 a_n148_n363# 0.17fF
C263 w_9_n211# G2_Not 0.09fF
C264 vdd C0_Inter_01 0.07fF
C265 A3 a_n147_n571# 0.16fF
C266 a_39_96# C0_Inter_01 0.04fF
C267 gnd C1_Inter_01 0.42fF
C268 P1_Not G2_Not 0.09fF
C269 w_121_n219# C2_Inter_01 0.02fF
C270 w_11_n71# a_24_n104# 0.09fF
C271 w_n109_n294# B2 0.06fF
C272 w_n108_n502# B3 0.06fF
C273 w_69_n123# C1_Inter_NOR 0.06fF
C274 w_9_n211# vdd 0.28fF
C275 w_210_n204# C2 0.02fF
C276 vdd P1_Not 0.13fF
C277 P0_Not a_24_n104# 0.02fF
C278 w_n164_n180# B1 0.40fF
C279 gnd C3_Inter_NOR 0.37fF
C280 w_121_n219# C2_Inter_NOR 0.06fF
C281 P3_Not C3_Inter_NOR 0.02fF
C282 C3_Inter_NAND a_46_n316# 0.09fF
C283 vdd a_73_n389# 0.01fF
C284 w_n160_n577# a_n147_n571# 0.02fF
C285 w_67_n263# vdd 0.19fF
C286 gnd a_n151_n174# 0.07fF
C287 a_22_n244# G2_Not 0.01fF
C288 w_n110_87# B0 0.06fF
C289 w_n162_127# A0 0.06fF
C290 w_31_49# vdd 0.07fF
C291 G3_Not a_46_n316# 0.24fF
C292 C2_Inter_01 a_223_n237# 0.03fF
C293 C0 C2_Inter_NAND 0.05fF
C294 w_n161_n369# a_n148_n363# 0.02fF
C295 B1 a_n151_n174# 0.17fF
C296 w_26_129# C0_Inter_01 0.05fF
C297 w_n108_n502# vdd 0.02fF
C298 gnd P2_Not 0.58fF
C299 gnd A2 0.26fF
C300 w_69_n123# vdd 0.19fF
C301 w_11_n71# G0_Not 0.06fF
C302 P2_Not P3_Not 0.03fF
C303 w_n164_n65# G1_Not 0.15fF
C304 w_n112_n105# A1 0.06fF
C305 Inter_S3 Gnd 0.08fF
C306 a_n147_n571# Gnd 0.61fF
C307 A3 Gnd 0.11fF
C308 B3 Gnd 0.42fF
C309 C3_Inter_NOR Gnd 0.16fF
C310 a_46_n316# Gnd 0.34fF
C311 G3_Not Gnd 0.12fF
C312 a_22_n384# Gnd 0.17fF
C313 Inter_S2 Gnd 0.08fF
C314 a_n148_n363# Gnd 0.61fF
C315 C3_Inter_NAND Gnd 0.63fF
C316 P3_Not Gnd 0.03fF
C317 C2 Gnd 0.01fF
C318 a_223_n237# Gnd 0.17fF
C319 a_134_n213# Gnd 0.43fF
C320 C2_Inter_NOR Gnd 0.15fF
C321 A2 Gnd 0.11fF
C322 B2 Gnd 0.42fF
C323 a_46_n176# Gnd 0.34fF
C324 G2_Not Gnd 0.12fF
C325 a_22_n244# Gnd 0.17fF
C326 P2_Not Gnd 0.04fF
C327 C2_Inter_NAND Gnd 2.25fF
C328 C2_Inter_01 Gnd 0.04fF
C329 Inter_S1 Gnd 0.08fF
C330 a_n151_n174# Gnd 0.61fF
C331 a_173_n86# Gnd 0.43fF
C332 C1_Inter_NOR Gnd 0.10fF
C333 C1 Gnd 0.02fF
C334 a_48_n36# Gnd 0.16fF
C335 a_248_n65# Gnd 0.17fF
C336 a_24_n104# Gnd 0.17fF
C337 P1_Not Gnd 0.05fF
C338 G1_Not Gnd 0.12fF
C339 A1 Gnd 0.11fF
C340 B1 Gnd 0.42fF
C341 C1_Inter_NAND Gnd 0.59fF
C342 C1_Inter_01 Gnd 0.06fF
C343 C0 Gnd 0.09fF
C344 Inter_S0 Gnd 0.08fF
C345 a_n149_18# Gnd 0.61fF
C346 C0_Inter_01 Gnd 0.11fF
C347 a_39_96# Gnd 0.04fF
C348 Cin Gnd 0.04fF
C349 gnd Gnd 11.80fF
C350 G0_Not Gnd 3.97fF
C351 vdd Gnd 8.31fF
C352 a_7_127# Gnd 0.29fF
C353 P0_Not Gnd 0.06fF
C354 A0 Gnd 0.99fF
C355 B0 Gnd 1.62fF
C356 w_n160_n577# Gnd 1.44fF
C357 w_n108_n502# Gnd 3.14fF
C358 w_n160_n462# Gnd 1.31fF
C359 w_67_n403# Gnd 0.82fF
C360 w_n161_n369# Gnd 1.44fF
C361 w_9_n351# Gnd 0.37fF
C362 w_67_n263# Gnd 0.82fF
C363 w_121_n219# Gnd 1.69fF
C364 w_n109_n294# Gnd 3.14fF
C365 w_n161_n254# Gnd 1.31fF
C366 w_210_n204# Gnd 2.34fF
C367 w_9_n211# Gnd 0.08fF
C368 w_n164_n180# Gnd 1.44fF
C369 w_160_n92# Gnd 1.69fF
C370 w_69_n123# Gnd 0.82fF
C371 w_11_n71# Gnd 0.37fF
C372 w_n112_n105# Gnd 3.14fF
C373 w_n164_n65# Gnd 1.31fF
C374 w_235_n32# Gnd 2.34fF
C375 w_n162_12# Gnd 1.44fF
C376 w_31_49# Gnd 1.09fF
C377 w_26_129# Gnd 2.34fF
C378 w_n6_144# Gnd 0.82fF
C379 w_n110_87# Gnd 0.90fF
C380 w_n162_127# Gnd 0.37fF
