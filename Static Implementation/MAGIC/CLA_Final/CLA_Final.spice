* SPICE3 file created from CLA_Final.ext - technology: scmos

.option scale=0.09u

M1000 vdd Cin a_173_n86# w_160_n92# pfet w=20 l=2
+  ad=8870 pd=4142 as=160 ps=56
M1001 gnd B2 P2_Not Gnd nfet w=40 l=2
+  ad=6071 pd=3066 as=320 ps=96
M1002 C0_Inter_01 a_39_96# vdd w_26_129# pfet w=22 l=2
+  ad=110 pd=54 as=0 ps=0
M1003 Inter_S3 B3 A3 w_n160_n577# pfet w=10 l=2
+  ad=110 pd=62 as=50 ps=30
M1004 G3_Not A3 a_n147_n515# Gnd nfet w=40 l=2
+  ad=240 pd=92 as=320 ps=96
M1005 C2_Inter_01 a_134_n213# vdd w_121_n219# pfet w=22 l=2
+  ad=110 pd=54 as=0 ps=0
M1006 a_88_n314# a_46_n316# gnd Gnd nfet w=20 l=2
+  ad=160 pd=56 as=0 ps=0
M1007 gnd P1_Not a_24_n104# Gnd nfet w=20 l=2
+  ad=0 pd=0 as=160 ps=56
M1008 Inter_S3 B3 a_n147_n571# Gnd nfet w=5 l=2
+  ad=30 pd=22 as=90 ps=56
M1009 Inter_S0 Cin S0 w_224_121# pfet w=10 l=2
+  ad=120 pd=64 as=60 ps=32
M1010 C1_Inter_NAND G1_Not a_90_n34# Gnd nfet w=20 l=2
+  ad=120 pd=52 as=160 ps=56
M1011 C1 a_248_n65# vdd w_235_n32# pfet w=22 l=2
+  ad=170 pd=86 as=0 ps=0
M1012 a_46_n316# a_22_n384# vdd w_9_n351# pfet w=22 l=2
+  ad=110 pd=54 as=0 ps=0
M1013 a_7_127# Cin gnd Gnd nfet w=11 l=2
+  ad=55 pd=32 as=0 ps=0
M1014 gnd P0_Not C1_Inter_NOR Gnd nfet w=5 l=2
+  ad=0 pd=0 as=40 ps=26
M1015 C3_Inter_NOR P3_Not gnd Gnd nfet w=5 l=2
+  ad=40 pd=26 as=0 ps=0
M1016 B0 A0 Inter_S0 w_n162_12# pfet w=10 l=2
+  ad=60 pd=32 as=0 ps=0
M1017 a_24_n104# P1_Not a_24_n65# w_11_n71# pfet w=40 l=2
+  ad=200 pd=90 as=320 ps=96
M1018 G0_Not B0 vdd w_n162_127# pfet w=40 l=2
+  ad=320 pd=96 as=0 ps=0
M1019 vdd C1_Inter_NOR C3_Inter_03 w_147_n442# pfet w=20 l=2
+  ad=0 pd=0 as=160 ps=56
M1020 gnd C3_Inter_NAND C3_Inter_02 Gnd nfet w=20 l=2
+  ad=0 pd=0 as=160 ps=56
M1021 Inter_S0 B0 a_n149_18# Gnd nfet w=5 l=2
+  ad=60 pd=44 as=90 ps=56
M1022 gnd P3_Not a_22_n384# Gnd nfet w=20 l=2
+  ad=0 pd=0 as=160 ps=56
M1023 C2_Inter_NOR P1_Not a_73_n249# w_67_n263# pfet w=10 l=2
+  ad=50 pd=30 as=80 ps=36
M1024 a_46_n176# a_22_n244# gnd Gnd nfet w=11 l=2
+  ad=55 pd=32 as=0 ps=0
M1025 P1_Not A1 gnd Gnd nfet w=40 l=2
+  ad=320 pd=96 as=0 ps=0
M1026 C2 Inter_S3 S3 w_270_n264# pfet w=10 l=2
+  ad=170 pd=86 as=60 ps=32
M1027 a_266_n416# C3_Inter_04 gnd Gnd nfet w=20 l=2
+  ad=160 pd=56 as=0 ps=0
M1028 S1 Inter_S1 C0 w_211_53# pfet w=10 l=2
+  ad=60 pd=32 as=210 ps=86
M1029 a_151_n355# C1_Inter_NAND a_151_n394# Gnd nfet w=20 l=2
+  ad=120 pd=52 as=160 ps=56
M1030 a_223_n237# C2_Inter_01 gnd Gnd nfet w=20 l=2
+  ad=160 pd=56 as=0 ps=0
M1031 C1 a_272_n166# S2 Gnd nfet w=5 l=2
+  ad=85 pd=54 as=30 ps=22
M1032 a_224_35# C0 gnd Gnd nfet w=11 l=2
+  ad=90 pd=56 as=0 ps=0
M1033 a_272_n166# Inter_S2 vdd w_259_n148# pfet w=22 l=2
+  ad=110 pd=54 as=0 ps=0
M1034 P2_Not B2 a_n96_n288# w_n109_n294# pfet w=80 l=2
+  ad=400 pd=170 as=640 ps=176
M1035 vdd A3 G3_Not w_n160_n462# pfet w=40 l=2
+  ad=0 pd=0 as=320 ps=96
M1036 a_22_n205# G1_Not vdd w_9_n211# pfet w=40 l=2
+  ad=320 pd=96 as=0 ps=0
M1037 a_134_n213# C2_Inter_NOR vdd w_121_n219# pfet w=20 l=2
+  ad=160 pd=56 as=0 ps=0
M1038 a_248_n65# C1_Inter_NAND a_248_n26# w_235_n32# pfet w=40 l=2
+  ad=200 pd=90 as=320 ps=96
M1039 a_211_n494# a_7_127# gnd Gnd nfet w=20 l=2
+  ad=160 pd=56 as=0 ps=0
M1040 Inter_S2 B2 A2 w_n161_n369# pfet w=10 l=2
+  ad=110 pd=62 as=50 ps=30
M1041 P0_Not A0 gnd Gnd nfet w=40 l=2
+  ad=320 pd=96 as=0 ps=0
M1042 a_n148_n307# B2 gnd Gnd nfet w=40 l=2
+  ad=320 pd=96 as=0 ps=0
M1043 Inter_S2 B2 a_n148_n363# Gnd nfet w=5 l=2
+  ad=30 pd=22 as=90 ps=56
M1044 a_88_n174# a_46_n176# gnd Gnd nfet w=20 l=2
+  ad=160 pd=56 as=0 ps=0
M1045 a_39_135# P0_Not vdd w_26_129# pfet w=40 l=2
+  ad=320 pd=96 as=0 ps=0
M1046 a_24_n104# G0_Not gnd Gnd nfet w=20 l=2
+  ad=0 pd=0 as=0 ps=0
M1047 P3_Not A3 gnd Gnd nfet w=40 l=2
+  ad=320 pd=96 as=0 ps=0
M1048 a_n148_n363# A2 vdd w_n161_n369# pfet w=22 l=2
+  ad=110 pd=54 as=0 ps=0
M1049 C1_Inter_01 a_173_n86# vdd w_160_n92# pfet w=22 l=2
+  ad=110 pd=54 as=0 ps=0
M1050 a_173_n86# C1_Inter_NOR vdd w_160_n92# pfet w=20 l=2
+  ad=0 pd=0 as=0 ps=0
M1051 gnd B1 P1_Not Gnd nfet w=40 l=2
+  ad=0 pd=0 as=0 ps=0
M1052 a_n148_n363# A2 gnd Gnd nfet w=11 l=2
+  ad=0 pd=0 as=0 ps=0
M1053 S0 Inter_S0 a_237_103# Gnd nfet w=5 l=2
+  ad=30 pd=22 as=90 ps=56
M1054 a_46_n176# a_22_n244# vdd w_9_n211# pfet w=22 l=2
+  ad=110 pd=54 as=0 ps=0
M1055 C3_Inter_03 C3_Inter_NOR vdd w_147_n442# pfet w=20 l=2
+  ad=0 pd=0 as=0 ps=0
M1056 C3_Inter_02 C3_Inter_01 gnd Gnd nfet w=20 l=2
+  ad=0 pd=0 as=0 ps=0
M1057 a_237_103# Cin vdd w_224_121# pfet w=22 l=2
+  ad=110 pd=54 as=0 ps=0
M1058 a_n99_n99# A1 vdd w_n112_n105# pfet w=80 l=2
+  ad=640 pd=176 as=0 ps=0
M1059 a_22_n384# G2_Not gnd Gnd nfet w=20 l=2
+  ad=0 pd=0 as=0 ps=0
M1060 C2_Inter_NOR P2_Not gnd Gnd nfet w=5 l=2
+  ad=40 pd=26 as=0 ps=0
M1061 gnd a_7_127# a_39_96# Gnd nfet w=20 l=2
+  ad=0 pd=0 as=160 ps=56
M1062 C3_Inter_NAND G3_Not a_88_n314# Gnd nfet w=20 l=2
+  ad=120 pd=52 as=0 ps=0
M1063 C1_Inter_NAND a_48_n36# vdd w_11_n71# pfet w=20 l=2
+  ad=160 pd=56 as=0 ps=0
M1064 a_134_n213# C0 a_134_n252# Gnd nfet w=20 l=2
+  ad=120 pd=52 as=160 ps=56
M1065 gnd P2_Not a_22_n244# Gnd nfet w=20 l=2
+  ad=0 pd=0 as=160 ps=56
M1066 gnd P2_Not C3_Inter_NOR Gnd nfet w=5 l=2
+  ad=0 pd=0 as=0 ps=0
M1067 vdd A0 G0_Not w_n162_127# pfet w=40 l=2
+  ad=0 pd=0 as=0 ps=0
M1068 a_n97_93# A0 vdd w_n110_87# pfet w=80 l=2
+  ad=640 pd=176 as=0 ps=0
M1069 a_24_n65# G0_Not vdd w_11_n71# pfet w=40 l=2
+  ad=0 pd=0 as=0 ps=0
M1070 C3_Inter_NAND a_46_n316# vdd w_9_n351# pfet w=20 l=2
+  ad=160 pd=56 as=0 ps=0
M1071 S1 Inter_S1 a_224_35# Gnd nfet w=5 l=2
+  ad=30 pd=22 as=0 ps=0
M1072 a_151_n394# C3_Inter_NOR gnd Gnd nfet w=20 l=2
+  ad=0 pd=0 as=0 ps=0
M1073 a_n149_18# A0 gnd Gnd nfet w=11 l=2
+  ad=0 pd=0 as=0 ps=0
M1074 S2 C1 Inter_S2 w_259_n148# pfet w=10 l=2
+  ad=60 pd=32 as=0 ps=0
M1075 C2 a_223_n237# gnd Gnd nfet w=11 l=2
+  ad=85 pd=54 as=0 ps=0
M1076 vdd C0_Inter_01 C0 w_31_49# pfet w=20 l=2
+  ad=0 pd=0 as=0 ps=0
M1077 a_48_n36# a_24_n104# gnd Gnd nfet w=11 l=2
+  ad=55 pd=32 as=0 ps=0
M1078 B3 A3 Inter_S3 w_n160_n577# pfet w=10 l=2
+  ad=60 pd=32 as=0 ps=0
M1079 G2_Not B2 vdd w_n161_n254# pfet w=40 l=2
+  ad=320 pd=96 as=0 ps=0
M1080 B3 a_n147_n571# Inter_S3 Gnd nfet w=5 l=2
+  ad=30 pd=22 as=0 ps=0
M1081 B1 A1 Inter_S1 w_n164_n180# pfet w=10 l=2
+  ad=60 pd=32 as=120 ps=64
M1082 vdd C3_Inter_02 C3 w_253_n383# pfet w=20 l=2
+  ad=0 pd=0 as=160 ps=56
M1083 a_283_n282# Inter_S3 vdd w_270_n264# pfet w=22 l=2
+  ad=110 pd=54 as=0 ps=0
M1084 a_75_n109# P1_Not vdd w_69_n123# pfet w=10 l=2
+  ad=80 pd=36 as=0 ps=0
M1085 B1 a_n151_n174# Inter_S1 Gnd nfet w=5 l=2
+  ad=30 pd=22 as=60 ps=44
M1086 C3_Inter_02 C3_Inter_NAND a_219_n311# w_206_n317# pfet w=40 l=2
+  ad=200 pd=90 as=320 ps=96
M1087 a_223_n237# C2_Inter_NAND a_223_n198# w_210_n204# pfet w=40 l=2
+  ad=200 pd=90 as=320 ps=96
M1088 Inter_S0 B0 A0 w_n162_12# pfet w=10 l=2
+  ad=0 pd=0 as=50 ps=30
M1089 a_n95_n496# A3 vdd w_n108_n502# pfet w=80 l=2
+  ad=640 pd=176 as=0 ps=0
M1090 a_n149_74# B0 gnd Gnd nfet w=40 l=2
+  ad=320 pd=96 as=0 ps=0
M1091 C3_Inter_04 a_211_n494# gnd Gnd nfet w=11 l=2
+  ad=55 pd=32 as=0 ps=0
M1092 C3_Inter_03 C1_Inter_NOR a_160_n475# Gnd nfet w=20 l=2
+  ad=120 pd=52 as=160 ps=56
M1093 G2_Not A2 a_n148_n307# Gnd nfet w=40 l=2
+  ad=240 pd=92 as=0 ps=0
M1094 a_237_103# Cin gnd Gnd nfet w=11 l=2
+  ad=0 pd=0 as=0 ps=0
M1095 gnd B0 P0_Not Gnd nfet w=40 l=2
+  ad=0 pd=0 as=0 ps=0
M1096 C2_Inter_01 a_134_n213# gnd Gnd nfet w=11 l=2
+  ad=55 pd=32 as=0 ps=0
M1097 a_73_n389# P3_Not vdd w_67_n403# pfet w=10 l=2
+  ad=80 pd=36 as=0 ps=0
M1098 S3 C2 Inter_S3 w_270_n264# pfet w=10 l=2
+  ad=0 pd=0 as=0 ps=0
M1099 C2 a_283_n282# S3 Gnd nfet w=5 l=2
+  ad=0 pd=0 as=30 ps=22
M1100 Inter_S0 a_237_103# S0 Gnd nfet w=5 l=2
+  ad=0 pd=0 as=0 ps=0
M1101 a_248_n26# C1_Inter_01 vdd w_235_n32# pfet w=40 l=2
+  ad=0 pd=0 as=0 ps=0
M1102 gnd B3 P3_Not Gnd nfet w=40 l=2
+  ad=0 pd=0 as=0 ps=0
M1103 a_n151_n118# B1 gnd Gnd nfet w=40 l=2
+  ad=320 pd=96 as=0 ps=0
M1104 C3_Inter_01 a_151_n355# vdd w_138_n361# pfet w=22 l=2
+  ad=110 pd=54 as=0 ps=0
M1105 G1_Not B1 vdd w_n164_n65# pfet w=40 l=2
+  ad=320 pd=96 as=0 ps=0
M1106 C2_Inter_NAND G2_Not a_88_n174# Gnd nfet w=20 l=2
+  ad=120 pd=52 as=0 ps=0
M1107 Inter_S1 C0 S1 w_211_53# pfet w=10 l=2
+  ad=0 pd=0 as=0 ps=0
M1108 C1 a_248_n65# gnd Gnd nfet w=11 l=2
+  ad=0 pd=0 as=0 ps=0
M1109 a_39_96# P0_Not gnd Gnd nfet w=20 l=2
+  ad=0 pd=0 as=0 ps=0
M1110 a_n151_n174# A1 vdd w_n164_n180# pfet w=22 l=2
+  ad=110 pd=54 as=0 ps=0
M1111 C2_Inter_NAND a_46_n176# vdd w_9_n211# pfet w=20 l=2
+  ad=160 pd=56 as=0 ps=0
M1112 a_211_n494# C3_Inter_03 a_211_n455# w_198_n461# pfet w=40 l=2
+  ad=200 pd=90 as=320 ps=96
M1113 a_22_n244# G1_Not gnd Gnd nfet w=20 l=2
+  ad=0 pd=0 as=0 ps=0
M1114 a_134_n252# C2_Inter_NOR gnd Gnd nfet w=20 l=2
+  ad=0 pd=0 as=0 ps=0
M1115 a_n151_n174# A1 gnd Gnd nfet w=11 l=2
+  ad=90 pd=56 as=0 ps=0
M1116 P0_Not B0 a_n97_93# w_n110_87# pfet w=80 l=2
+  ad=400 pd=170 as=0 ps=0
M1117 a_48_n36# a_24_n104# vdd w_11_n71# pfet w=22 l=2
+  ad=110 pd=54 as=0 ps=0
M1118 gnd C1_Inter_NAND a_248_n65# Gnd nfet w=20 l=2
+  ad=0 pd=0 as=160 ps=56
M1119 C1_Inter_01 a_173_n86# gnd Gnd nfet w=11 l=2
+  ad=55 pd=32 as=0 ps=0
M1120 gnd P1_Not C2_Inter_NOR Gnd nfet w=5 l=2
+  ad=0 pd=0 as=0 ps=0
M1121 a_272_n166# Inter_S2 gnd Gnd nfet w=11 l=2
+  ad=90 pd=56 as=0 ps=0
M1122 vdd A2 G2_Not w_n161_n254# pfet w=40 l=2
+  ad=0 pd=0 as=0 ps=0
M1123 C0 C0_Inter_01 a_44_16# Gnd nfet w=20 l=2
+  ad=120 pd=52 as=160 ps=56
M1124 vdd G1_Not C1_Inter_NAND w_11_n71# pfet w=20 l=2
+  ad=0 pd=0 as=0 ps=0
M1125 C0 G0_Not vdd w_31_49# pfet w=20 l=2
+  ad=0 pd=0 as=0 ps=0
M1126 a_283_n282# Inter_S3 gnd Gnd nfet w=11 l=2
+  ad=90 pd=56 as=0 ps=0
M1127 C3 C3_Inter_04 vdd w_253_n383# pfet w=20 l=2
+  ad=0 pd=0 as=0 ps=0
M1128 C3_Inter_04 a_211_n494# vdd w_198_n461# pfet w=22 l=2
+  ad=110 pd=54 as=0 ps=0
M1129 a_219_n311# C3_Inter_01 vdd w_206_n317# pfet w=40 l=2
+  ad=0 pd=0 as=0 ps=0
M1130 vdd G3_Not C3_Inter_NAND w_9_n351# pfet w=20 l=2
+  ad=0 pd=0 as=0 ps=0
M1131 B0 a_n149_18# Inter_S0 Gnd nfet w=5 l=2
+  ad=30 pd=22 as=0 ps=0
M1132 a_22_n384# P3_Not a_22_n345# w_9_n351# pfet w=40 l=2
+  ad=200 pd=90 as=320 ps=96
M1133 a_223_n198# C2_Inter_01 vdd w_210_n204# pfet w=40 l=2
+  ad=0 pd=0 as=0 ps=0
M1134 P1_Not B1 a_n99_n99# w_n112_n105# pfet w=80 l=2
+  ad=400 pd=170 as=0 ps=0
M1135 P3_Not B3 a_n95_n496# w_n108_n502# pfet w=80 l=2
+  ad=400 pd=170 as=0 ps=0
M1136 a_160_n475# C3_Inter_NOR gnd Gnd nfet w=20 l=2
+  ad=0 pd=0 as=0 ps=0
M1137 G0_Not A0 a_n149_74# Gnd nfet w=40 l=2
+  ad=240 pd=92 as=0 ps=0
M1138 a_90_n34# a_48_n36# gnd Gnd nfet w=20 l=2
+  ad=0 pd=0 as=0 ps=0
M1139 a_173_n86# Cin a_173_n125# Gnd nfet w=20 l=2
+  ad=120 pd=52 as=160 ps=56
M1140 C1 Inter_S2 S2 w_259_n148# pfet w=10 l=2
+  ad=0 pd=0 as=0 ps=0
M1141 C1_Inter_NOR P1_Not gnd Gnd nfet w=5 l=2
+  ad=0 pd=0 as=0 ps=0
M1142 vdd C1_Inter_NAND a_151_n355# w_138_n361# pfet w=20 l=2
+  ad=0 pd=0 as=160 ps=56
M1143 C1_Inter_NOR P0_Not a_75_n109# w_69_n123# pfet w=10 l=2
+  ad=50 pd=30 as=0 ps=0
M1144 P2_Not A2 gnd Gnd nfet w=40 l=2
+  ad=0 pd=0 as=0 ps=0
M1145 a_n147_n515# B3 gnd Gnd nfet w=40 l=2
+  ad=0 pd=0 as=0 ps=0
M1146 a_n149_18# A0 vdd w_n162_12# pfet w=22 l=2
+  ad=110 pd=54 as=0 ps=0
M1147 G1_Not A1 a_n151_n118# Gnd nfet w=40 l=2
+  ad=240 pd=92 as=0 ps=0
M1148 Inter_S1 B1 A1 w_n164_n180# pfet w=10 l=2
+  ad=0 pd=0 as=50 ps=30
M1149 C3_Inter_01 a_151_n355# gnd Gnd nfet w=11 l=2
+  ad=55 pd=32 as=0 ps=0
M1150 a_73_n249# P2_Not vdd w_67_n263# pfet w=10 l=2
+  ad=0 pd=0 as=0 ps=0
M1151 S2 C1 a_272_n166# Gnd nfet w=5 l=2
+  ad=0 pd=0 as=0 ps=0
M1152 Inter_S1 B1 a_n151_n174# Gnd nfet w=5 l=2
+  ad=0 pd=0 as=0 ps=0
M1153 C2 a_223_n237# vdd w_210_n204# pfet w=22 l=2
+  ad=0 pd=0 as=0 ps=0
M1154 Inter_S1 a_224_35# S1 Gnd nfet w=5 l=2
+  ad=0 pd=0 as=0 ps=0
M1155 a_n147_n571# A3 vdd w_n160_n577# pfet w=22 l=2
+  ad=110 pd=54 as=0 ps=0
M1156 C3_Inter_NOR P2_Not a_73_n389# w_67_n403# pfet w=10 l=2
+  ad=50 pd=30 as=0 ps=0
M1157 S0 Inter_S0 Cin w_224_121# pfet w=10 l=2
+  ad=0 pd=0 as=50 ps=30
M1158 a_46_n316# a_22_n384# gnd Gnd nfet w=11 l=2
+  ad=55 pd=32 as=0 ps=0
M1159 a_211_n455# a_7_127# vdd w_198_n461# pfet w=40 l=2
+  ad=0 pd=0 as=0 ps=0
M1160 a_n147_n571# A3 gnd Gnd nfet w=11 l=2
+  ad=0 pd=0 as=0 ps=0
M1161 vdd A1 G1_Not w_n164_n65# pfet w=40 l=2
+  ad=0 pd=0 as=0 ps=0
M1162 C0_Inter_01 a_39_96# gnd Gnd nfet w=11 l=2
+  ad=55 pd=32 as=0 ps=0
M1163 B2 A2 Inter_S2 w_n161_n369# pfet w=10 l=2
+  ad=60 pd=32 as=0 ps=0
M1164 C3 C3_Inter_02 a_266_n416# Gnd nfet w=20 l=2
+  ad=120 pd=52 as=0 ps=0
M1165 B2 a_n148_n363# Inter_S2 Gnd nfet w=5 l=2
+  ad=30 pd=22 as=0 ps=0
M1166 gnd C2_Inter_NAND a_223_n237# Gnd nfet w=20 l=2
+  ad=0 pd=0 as=0 ps=0
M1167 vdd G2_Not C2_Inter_NAND w_9_n211# pfet w=20 l=2
+  ad=0 pd=0 as=0 ps=0
M1168 S3 C2 a_283_n282# Gnd nfet w=5 l=2
+  ad=0 pd=0 as=0 ps=0
M1169 a_44_16# G0_Not gnd Gnd nfet w=20 l=2
+  ad=0 pd=0 as=0 ps=0
M1170 a_248_n65# C1_Inter_01 gnd Gnd nfet w=20 l=2
+  ad=0 pd=0 as=0 ps=0
M1171 a_n96_n288# A2 vdd w_n109_n294# pfet w=80 l=2
+  ad=0 pd=0 as=0 ps=0
M1172 G3_Not B3 vdd w_n160_n462# pfet w=40 l=2
+  ad=0 pd=0 as=0 ps=0
M1173 a_22_n345# G2_Not vdd w_9_n351# pfet w=40 l=2
+  ad=0 pd=0 as=0 ps=0
M1174 a_7_127# Cin vdd w_n6_144# pfet w=22 l=2
+  ad=110 pd=54 as=0 ps=0
M1175 a_22_n244# P2_Not a_22_n205# w_9_n211# pfet w=40 l=2
+  ad=200 pd=90 as=0 ps=0
M1176 a_39_96# a_7_127# a_39_135# w_26_129# pfet w=40 l=2
+  ad=200 pd=90 as=0 ps=0
M1177 vdd C0 a_134_n213# w_121_n219# pfet w=20 l=2
+  ad=0 pd=0 as=0 ps=0
M1178 a_173_n125# C1_Inter_NOR gnd Gnd nfet w=20 l=2
+  ad=0 pd=0 as=0 ps=0
M1179 gnd C3_Inter_03 a_211_n494# Gnd nfet w=20 l=2
+  ad=0 pd=0 as=0 ps=0
M1180 a_224_35# C0 vdd w_211_53# pfet w=22 l=2
+  ad=110 pd=54 as=0 ps=0
M1181 a_151_n355# C3_Inter_NOR vdd w_138_n361# pfet w=20 l=2
+  ad=0 pd=0 as=0 ps=0
C0 vdd gnd 2.24fF
C1 C3_Inter_NAND Gnd 2.00fF
C2 Inter_S3 Gnd 8.01fF
C3 P2_Not Gnd 2.82fF
C4 C2_Inter_NAND Gnd 2.25fF
C5 Inter_S2 Gnd 2.08fF
C6 C1_Inter_NOR Gnd 2.56fF
C7 P1_Not Gnd 2.74fF
C8 C1_Inter_NAND Gnd 2.95fF
C9 Inter_S1 Gnd 4.39fF
C10 Inter_S0 Gnd 4.34fF
C11 gnd Gnd 15.65fF
C12 G0_Not Gnd 3.97fF
C13 vdd Gnd 12.71fF
C14 a_7_127# Gnd 4.69fF
C15 P0_Not Gnd 4.11fF
C16 w_198_n461# Gnd 2.34fF
C17 w_n108_n502# Gnd 3.14fF
C18 w_n109_n294# Gnd 3.14fF
C19 w_210_n204# Gnd 2.34fF
C20 w_n112_n105# Gnd 3.14fF
C21 w_235_n32# Gnd 2.34fF
C22 w_26_129# Gnd 2.34fF
