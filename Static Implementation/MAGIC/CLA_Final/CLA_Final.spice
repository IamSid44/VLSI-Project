* SPICE3 file created from CLA_Final.ext - technology: scmos

.option scale=0.09u

M1000 vdd Cin a_173_n86# w_160_n92# pfet w=20 l=2
+  ad=8760 pd=4088 as=160 ps=56
M1001 gnd B2 P2_Not Gnd nfet w=40 l=2
+  ad=6016 pd=3034 as=320 ps=96
M1002 C0_Inter_01 a_39_96# vdd w_26_129# pfet w=22 l=2
+  ad=110 pd=54 as=0 ps=0
M1003 Inter_S3 B3 A3 w_n160_n577# pfet w=10 l=2
+  ad=60 pd=32 as=50 ps=30
M1004 G3_Not A3 a_n147_n515# Gnd nfet w=40 l=2
+  ad=240 pd=92 as=320 ps=96
M1005 C2_Inter_01 a_134_n213# vdd w_121_n219# pfet w=22 l=2
+  ad=110 pd=54 as=0 ps=0
M1006 a_88_n314# a_46_n316# gnd Gnd nfet w=20 l=2
+  ad=160 pd=56 as=0 ps=0
M1007 gnd P1_Not a_24_n104# Gnd nfet w=20 l=2
+  ad=0 pd=0 as=160 ps=56
M1008 Inter_S3 B3 a_n147_n571# Gnd nfet w=5 l=2
+  ad=30 pd=22 as=90 ps=56
M1009 Inter_S0 Cin S0 w_224_121# pfet w=10 l=2
+  ad=120 pd=64 as=60 ps=32
M1010 C1_Inter_NAND G1_Not a_90_n34# Gnd nfet w=20 l=2
+  ad=120 pd=52 as=160 ps=56
M1011 C1 a_248_n65# vdd w_235_n32# pfet w=22 l=2
+  ad=170 pd=86 as=0 ps=0
M1012 a_46_n316# a_22_n384# vdd w_9_n351# pfet w=22 l=2
+  ad=110 pd=54 as=0 ps=0
M1013 a_7_127# Cin gnd Gnd nfet w=11 l=2
+  ad=55 pd=32 as=0 ps=0
M1014 gnd P0_Not C1_Inter_NOR Gnd nfet w=5 l=2
+  ad=0 pd=0 as=40 ps=26
M1015 C3_Inter_NOR P3_Not gnd Gnd nfet w=5 l=2
+  ad=40 pd=26 as=0 ps=0
M1016 B0 A0 Inter_S0 w_n162_12# pfet w=10 l=2
+  ad=60 pd=32 as=0 ps=0
M1017 a_24_n104# P1_Not a_24_n65# w_11_n71# pfet w=40 l=2
+  ad=200 pd=90 as=320 ps=96
M1018 G0_Not B0 vdd w_n162_127# pfet w=40 l=2
+  ad=320 pd=96 as=0 ps=0
M1019 vdd C1_Inter_NOR C3_Inter_03 w_147_n442# pfet w=20 l=2
+  ad=0 pd=0 as=160 ps=56
M1020 gnd C3_Inter_NAND C3_Inter_02 Gnd nfet w=20 l=2
+  ad=0 pd=0 as=160 ps=56
M1021 Inter_S0 B0 a_n149_18# Gnd nfet w=5 l=2
+  ad=60 pd=44 as=90 ps=56
M1022 gnd P3_Not a_22_n384# Gnd nfet w=20 l=2
+  ad=0 pd=0 as=160 ps=56
M1023 C2_Inter_NOR P1_Not a_73_n249# w_67_n263# pfet w=10 l=2
+  ad=50 pd=30 as=80 ps=36
M1024 a_46_n176# a_22_n244# gnd Gnd nfet w=11 l=2
+  ad=55 pd=32 as=0 ps=0
M1025 P1_Not A1 gnd Gnd nfet w=40 l=2
+  ad=320 pd=96 as=0 ps=0
M1026 a_266_n416# C3_Inter_04 gnd Gnd nfet w=20 l=2
+  ad=160 pd=56 as=0 ps=0
M1027 S1 Inter_S1 C0 w_211_53# pfet w=10 l=2
+  ad=60 pd=32 as=210 ps=86
M1028 a_151_n355# C1_Inter_NAND a_151_n394# Gnd nfet w=20 l=2
+  ad=120 pd=52 as=160 ps=56
M1029 a_223_n237# C2_Inter_01 gnd Gnd nfet w=20 l=2
+  ad=160 pd=56 as=0 ps=0
M1030 C1 a_272_n166# S2 Gnd nfet w=5 l=2
+  ad=85 pd=54 as=30 ps=22
M1031 a_224_35# C0 gnd Gnd nfet w=11 l=2
+  ad=90 pd=56 as=0 ps=0
M1032 a_272_n166# Inter_S2 vdd w_259_n148# pfet w=22 l=2
+  ad=110 pd=54 as=0 ps=0
M1033 P2_Not B2 a_n96_n288# w_n109_n294# pfet w=80 l=2
+  ad=400 pd=170 as=640 ps=176
M1034 vdd A3 G3_Not w_n160_n462# pfet w=40 l=2
+  ad=0 pd=0 as=320 ps=96
M1035 a_22_n205# G1_Not vdd w_9_n211# pfet w=40 l=2
+  ad=320 pd=96 as=0 ps=0
M1036 a_134_n213# C2_Inter_NOR vdd w_121_n219# pfet w=20 l=2
+  ad=160 pd=56 as=0 ps=0
M1037 a_248_n65# C1_Inter_NAND a_248_n26# w_235_n32# pfet w=40 l=2
+  ad=200 pd=90 as=320 ps=96
M1038 a_211_n494# a_7_127# gnd Gnd nfet w=20 l=2
+  ad=160 pd=56 as=0 ps=0
M1039 Inter_S2 B2 A2 w_n161_n369# pfet w=10 l=2
+  ad=110 pd=62 as=50 ps=30
M1040 P0_Not A0 gnd Gnd nfet w=40 l=2
+  ad=320 pd=96 as=0 ps=0
M1041 a_n148_n307# B2 gnd Gnd nfet w=40 l=2
+  ad=320 pd=96 as=0 ps=0
M1042 Inter_S2 B2 a_n148_n363# Gnd nfet w=5 l=2
+  ad=30 pd=22 as=90 ps=56
M1043 a_88_n174# a_46_n176# gnd Gnd nfet w=20 l=2
+  ad=160 pd=56 as=0 ps=0
M1044 a_39_135# P0_Not vdd w_26_129# pfet w=40 l=2
+  ad=320 pd=96 as=0 ps=0
M1045 a_24_n104# G0_Not gnd Gnd nfet w=20 l=2
+  ad=0 pd=0 as=0 ps=0
M1046 P3_Not A3 gnd Gnd nfet w=40 l=2
+  ad=320 pd=96 as=0 ps=0
M1047 a_n148_n363# A2 vdd w_n161_n369# pfet w=22 l=2
+  ad=110 pd=54 as=0 ps=0
M1048 C1_Inter_01 a_173_n86# vdd w_160_n92# pfet w=22 l=2
+  ad=110 pd=54 as=0 ps=0
M1049 a_173_n86# C1_Inter_NOR vdd w_160_n92# pfet w=20 l=2
+  ad=0 pd=0 as=0 ps=0
M1050 gnd B1 P1_Not Gnd nfet w=40 l=2
+  ad=0 pd=0 as=0 ps=0
M1051 a_n148_n363# A2 gnd Gnd nfet w=11 l=2
+  ad=0 pd=0 as=0 ps=0
M1052 S0 Inter_S0 a_237_103# Gnd nfet w=5 l=2
+  ad=30 pd=22 as=90 ps=56
M1053 a_46_n176# a_22_n244# vdd w_9_n211# pfet w=22 l=2
+  ad=110 pd=54 as=0 ps=0
M1054 C3_Inter_03 C3_Inter_NOR vdd w_147_n442# pfet w=20 l=2
+  ad=0 pd=0 as=0 ps=0
M1055 C3_Inter_02 C3_Inter_01 gnd Gnd nfet w=20 l=2
+  ad=0 pd=0 as=0 ps=0
M1056 a_237_103# Cin vdd w_224_121# pfet w=22 l=2
+  ad=110 pd=54 as=0 ps=0
M1057 a_n99_n99# A1 vdd w_n112_n105# pfet w=80 l=2
+  ad=640 pd=176 as=0 ps=0
M1058 a_22_n384# G2_Not gnd Gnd nfet w=20 l=2
+  ad=0 pd=0 as=0 ps=0
M1059 C2_Inter_NOR P2_Not gnd Gnd nfet w=5 l=2
+  ad=40 pd=26 as=0 ps=0
M1060 gnd a_7_127# a_39_96# Gnd nfet w=20 l=2
+  ad=0 pd=0 as=160 ps=56
M1061 C3_Inter_NAND G3_Not a_88_n314# Gnd nfet w=20 l=2
+  ad=120 pd=52 as=0 ps=0
M1062 C1_Inter_NAND a_48_n36# vdd w_11_n71# pfet w=20 l=2
+  ad=160 pd=56 as=0 ps=0
M1063 a_134_n213# C0 a_134_n252# Gnd nfet w=20 l=2
+  ad=120 pd=52 as=160 ps=56
M1064 gnd P2_Not a_22_n244# Gnd nfet w=20 l=2
+  ad=0 pd=0 as=160 ps=56
M1065 gnd P2_Not C3_Inter_NOR Gnd nfet w=5 l=2
+  ad=0 pd=0 as=0 ps=0
M1066 vdd A0 G0_Not w_n162_127# pfet w=40 l=2
+  ad=0 pd=0 as=0 ps=0
M1067 a_n97_93# A0 vdd w_n110_87# pfet w=80 l=2
+  ad=640 pd=176 as=0 ps=0
M1068 a_24_n65# G0_Not vdd w_11_n71# pfet w=40 l=2
+  ad=0 pd=0 as=0 ps=0
M1069 C3_Inter_NAND a_46_n316# vdd w_9_n351# pfet w=20 l=2
+  ad=160 pd=56 as=0 ps=0
M1070 S1 Inter_S1 a_224_35# Gnd nfet w=5 l=2
+  ad=30 pd=22 as=0 ps=0
M1071 a_151_n394# C3_Inter_NOR gnd Gnd nfet w=20 l=2
+  ad=0 pd=0 as=0 ps=0
M1072 a_n149_18# A0 gnd Gnd nfet w=11 l=2
+  ad=0 pd=0 as=0 ps=0
M1073 S2 C1 Inter_S2 w_259_n148# pfet w=10 l=2
+  ad=60 pd=32 as=0 ps=0
M1074 C2 a_223_n237# gnd Gnd nfet w=11 l=2
+  ad=55 pd=32 as=0 ps=0
M1075 vdd C0_Inter_01 C0 w_31_49# pfet w=20 l=2
+  ad=0 pd=0 as=0 ps=0
M1076 a_48_n36# a_24_n104# gnd Gnd nfet w=11 l=2
+  ad=55 pd=32 as=0 ps=0
M1077 B3 A3 Inter_S3 w_n160_n577# pfet w=10 l=2
+  ad=60 pd=32 as=0 ps=0
M1078 G2_Not B2 vdd w_n161_n254# pfet w=40 l=2
+  ad=320 pd=96 as=0 ps=0
M1079 B3 a_n147_n571# Inter_S3 Gnd nfet w=5 l=2
+  ad=30 pd=22 as=0 ps=0
M1080 B1 A1 Inter_S1 w_n164_n180# pfet w=10 l=2
+  ad=60 pd=32 as=120 ps=64
M1081 vdd C3_Inter_02 C3 w_253_n383# pfet w=20 l=2
+  ad=0 pd=0 as=160 ps=56
M1082 a_75_n109# P1_Not vdd w_69_n123# pfet w=10 l=2
+  ad=80 pd=36 as=0 ps=0
M1083 B1 a_n151_n174# Inter_S1 Gnd nfet w=5 l=2
+  ad=30 pd=22 as=60 ps=44
M1084 C3_Inter_02 C3_Inter_NAND a_219_n311# w_206_n317# pfet w=40 l=2
+  ad=200 pd=90 as=320 ps=96
M1085 a_223_n237# C2_Inter_NAND a_223_n198# w_210_n204# pfet w=40 l=2
+  ad=200 pd=90 as=320 ps=96
M1086 Inter_S0 B0 A0 w_n162_12# pfet w=10 l=2
+  ad=0 pd=0 as=50 ps=30
M1087 a_n95_n496# A3 vdd w_n108_n502# pfet w=80 l=2
+  ad=640 pd=176 as=0 ps=0
M1088 a_n149_74# B0 gnd Gnd nfet w=40 l=2
+  ad=320 pd=96 as=0 ps=0
M1089 C3_Inter_04 a_211_n494# gnd Gnd nfet w=11 l=2
+  ad=55 pd=32 as=0 ps=0
M1090 C3_Inter_03 C1_Inter_NOR a_160_n475# Gnd nfet w=20 l=2
+  ad=120 pd=52 as=160 ps=56
M1091 G2_Not A2 a_n148_n307# Gnd nfet w=40 l=2
+  ad=240 pd=92 as=0 ps=0
M1092 a_237_103# Cin gnd Gnd nfet w=11 l=2
+  ad=0 pd=0 as=0 ps=0
M1093 gnd B0 P0_Not Gnd nfet w=40 l=2
+  ad=0 pd=0 as=0 ps=0
M1094 C2_Inter_01 a_134_n213# gnd Gnd nfet w=11 l=2
+  ad=55 pd=32 as=0 ps=0
M1095 a_73_n389# P3_Not vdd w_67_n403# pfet w=10 l=2
+  ad=80 pd=36 as=0 ps=0
M1096 Inter_S0 a_237_103# S0 Gnd nfet w=5 l=2
+  ad=0 pd=0 as=0 ps=0
M1097 a_248_n26# C1_Inter_01 vdd w_235_n32# pfet w=40 l=2
+  ad=0 pd=0 as=0 ps=0
M1098 gnd B3 P3_Not Gnd nfet w=40 l=2
+  ad=0 pd=0 as=0 ps=0
M1099 a_n151_n118# B1 gnd Gnd nfet w=40 l=2
+  ad=320 pd=96 as=0 ps=0
M1100 C3_Inter_01 a_151_n355# vdd w_138_n361# pfet w=22 l=2
+  ad=110 pd=54 as=0 ps=0
M1101 G1_Not B1 vdd w_n164_n65# pfet w=40 l=2
+  ad=320 pd=96 as=0 ps=0
M1102 C2_Inter_NAND G2_Not a_88_n174# Gnd nfet w=20 l=2
+  ad=120 pd=52 as=0 ps=0
M1103 Inter_S1 C0 S1 w_211_53# pfet w=10 l=2
+  ad=0 pd=0 as=0 ps=0
M1104 C1 a_248_n65# gnd Gnd nfet w=11 l=2
+  ad=0 pd=0 as=0 ps=0
M1105 a_39_96# P0_Not gnd Gnd nfet w=20 l=2
+  ad=0 pd=0 as=0 ps=0
M1106 a_n151_n174# A1 vdd w_n164_n180# pfet w=22 l=2
+  ad=110 pd=54 as=0 ps=0
M1107 a_211_n494# C3_Inter_03 a_211_n455# w_198_n461# pfet w=40 l=2
+  ad=200 pd=90 as=320 ps=96
M1108 C2_Inter_NAND a_46_n176# vdd w_9_n211# pfet w=20 l=2
+  ad=160 pd=56 as=0 ps=0
M1109 a_22_n244# G1_Not gnd Gnd nfet w=20 l=2
+  ad=0 pd=0 as=0 ps=0
M1110 a_134_n252# C2_Inter_NOR gnd Gnd nfet w=20 l=2
+  ad=0 pd=0 as=0 ps=0
M1111 a_n151_n174# A1 gnd Gnd nfet w=11 l=2
+  ad=90 pd=56 as=0 ps=0
M1112 P0_Not B0 a_n97_93# w_n110_87# pfet w=80 l=2
+  ad=400 pd=170 as=0 ps=0
M1113 a_48_n36# a_24_n104# vdd w_11_n71# pfet w=22 l=2
+  ad=110 pd=54 as=0 ps=0
M1114 gnd C1_Inter_NAND a_248_n65# Gnd nfet w=20 l=2
+  ad=0 pd=0 as=160 ps=56
M1115 C1_Inter_01 a_173_n86# gnd Gnd nfet w=11 l=2
+  ad=55 pd=32 as=0 ps=0
M1116 gnd P1_Not C2_Inter_NOR Gnd nfet w=5 l=2
+  ad=0 pd=0 as=0 ps=0
M1117 a_272_n166# Inter_S2 gnd Gnd nfet w=11 l=2
+  ad=90 pd=56 as=0 ps=0
M1118 vdd A2 G2_Not w_n161_n254# pfet w=40 l=2
+  ad=0 pd=0 as=0 ps=0
M1119 C0 C0_Inter_01 a_44_16# Gnd nfet w=20 l=2
+  ad=120 pd=52 as=160 ps=56
M1120 vdd G1_Not C1_Inter_NAND w_11_n71# pfet w=20 l=2
+  ad=0 pd=0 as=0 ps=0
M1121 C0 G0_Not vdd w_31_49# pfet w=20 l=2
+  ad=0 pd=0 as=0 ps=0
M1122 C3 C3_Inter_04 vdd w_253_n383# pfet w=20 l=2
+  ad=0 pd=0 as=0 ps=0
M1123 C3_Inter_04 a_211_n494# vdd w_198_n461# pfet w=22 l=2
+  ad=110 pd=54 as=0 ps=0
M1124 a_219_n311# C3_Inter_01 vdd w_206_n317# pfet w=40 l=2
+  ad=0 pd=0 as=0 ps=0
M1125 vdd G3_Not C3_Inter_NAND w_9_n351# pfet w=20 l=2
+  ad=0 pd=0 as=0 ps=0
M1126 B0 a_n149_18# Inter_S0 Gnd nfet w=5 l=2
+  ad=30 pd=22 as=0 ps=0
M1127 a_22_n384# P3_Not a_22_n345# w_9_n351# pfet w=40 l=2
+  ad=200 pd=90 as=320 ps=96
M1128 a_223_n198# C2_Inter_01 vdd w_210_n204# pfet w=40 l=2
+  ad=0 pd=0 as=0 ps=0
M1129 P1_Not B1 a_n99_n99# w_n112_n105# pfet w=80 l=2
+  ad=400 pd=170 as=0 ps=0
M1130 P3_Not B3 a_n95_n496# w_n108_n502# pfet w=80 l=2
+  ad=400 pd=170 as=0 ps=0
M1131 a_160_n475# C3_Inter_NOR gnd Gnd nfet w=20 l=2
+  ad=0 pd=0 as=0 ps=0
M1132 G0_Not A0 a_n149_74# Gnd nfet w=40 l=2
+  ad=240 pd=92 as=0 ps=0
M1133 a_90_n34# a_48_n36# gnd Gnd nfet w=20 l=2
+  ad=0 pd=0 as=0 ps=0
M1134 a_173_n86# Cin a_173_n125# Gnd nfet w=20 l=2
+  ad=120 pd=52 as=160 ps=56
M1135 C1 Inter_S2 S2 w_259_n148# pfet w=10 l=2
+  ad=0 pd=0 as=0 ps=0
M1136 C1_Inter_NOR P1_Not gnd Gnd nfet w=5 l=2
+  ad=0 pd=0 as=0 ps=0
M1137 vdd C1_Inter_NAND a_151_n355# w_138_n361# pfet w=20 l=2
+  ad=0 pd=0 as=160 ps=56
M1138 C1_Inter_NOR P0_Not a_75_n109# w_69_n123# pfet w=10 l=2
+  ad=50 pd=30 as=0 ps=0
M1139 P2_Not A2 gnd Gnd nfet w=40 l=2
+  ad=0 pd=0 as=0 ps=0
M1140 a_n147_n515# B3 gnd Gnd nfet w=40 l=2
+  ad=0 pd=0 as=0 ps=0
M1141 a_n149_18# A0 vdd w_n162_12# pfet w=22 l=2
+  ad=110 pd=54 as=0 ps=0
M1142 G1_Not A1 a_n151_n118# Gnd nfet w=40 l=2
+  ad=240 pd=92 as=0 ps=0
M1143 Inter_S1 B1 A1 w_n164_n180# pfet w=10 l=2
+  ad=0 pd=0 as=50 ps=30
M1144 C3_Inter_01 a_151_n355# gnd Gnd nfet w=11 l=2
+  ad=55 pd=32 as=0 ps=0
M1145 a_73_n249# P2_Not vdd w_67_n263# pfet w=10 l=2
+  ad=0 pd=0 as=0 ps=0
M1146 S2 C1 a_272_n166# Gnd nfet w=5 l=2
+  ad=0 pd=0 as=0 ps=0
M1147 Inter_S1 B1 a_n151_n174# Gnd nfet w=5 l=2
+  ad=0 pd=0 as=0 ps=0
M1148 C2 a_223_n237# vdd w_210_n204# pfet w=22 l=2
+  ad=110 pd=54 as=0 ps=0
M1149 Inter_S1 a_224_35# S1 Gnd nfet w=5 l=2
+  ad=0 pd=0 as=0 ps=0
M1150 a_n147_n571# A3 vdd w_n160_n577# pfet w=22 l=2
+  ad=110 pd=54 as=0 ps=0
M1151 C3_Inter_NOR P2_Not a_73_n389# w_67_n403# pfet w=10 l=2
+  ad=50 pd=30 as=0 ps=0
M1152 S0 Inter_S0 Cin w_224_121# pfet w=10 l=2
+  ad=0 pd=0 as=50 ps=30
M1153 a_46_n316# a_22_n384# gnd Gnd nfet w=11 l=2
+  ad=55 pd=32 as=0 ps=0
M1154 a_211_n455# a_7_127# vdd w_198_n461# pfet w=40 l=2
+  ad=0 pd=0 as=0 ps=0
M1155 a_n147_n571# A3 gnd Gnd nfet w=11 l=2
+  ad=0 pd=0 as=0 ps=0
M1156 vdd A1 G1_Not w_n164_n65# pfet w=40 l=2
+  ad=0 pd=0 as=0 ps=0
M1157 C0_Inter_01 a_39_96# gnd Gnd nfet w=11 l=2
+  ad=55 pd=32 as=0 ps=0
M1158 B2 A2 Inter_S2 w_n161_n369# pfet w=10 l=2
+  ad=60 pd=32 as=0 ps=0
M1159 C3 C3_Inter_02 a_266_n416# Gnd nfet w=20 l=2
+  ad=120 pd=52 as=0 ps=0
M1160 B2 a_n148_n363# Inter_S2 Gnd nfet w=5 l=2
+  ad=30 pd=22 as=0 ps=0
M1161 gnd C2_Inter_NAND a_223_n237# Gnd nfet w=20 l=2
+  ad=0 pd=0 as=0 ps=0
M1162 vdd G2_Not C2_Inter_NAND w_9_n211# pfet w=20 l=2
+  ad=0 pd=0 as=0 ps=0
M1163 a_44_16# G0_Not gnd Gnd nfet w=20 l=2
+  ad=0 pd=0 as=0 ps=0
M1164 a_248_n65# C1_Inter_01 gnd Gnd nfet w=20 l=2
+  ad=0 pd=0 as=0 ps=0
M1165 a_n96_n288# A2 vdd w_n109_n294# pfet w=80 l=2
+  ad=0 pd=0 as=0 ps=0
M1166 G3_Not B3 vdd w_n160_n462# pfet w=40 l=2
+  ad=0 pd=0 as=0 ps=0
M1167 a_22_n345# G2_Not vdd w_9_n351# pfet w=40 l=2
+  ad=0 pd=0 as=0 ps=0
M1168 a_7_127# Cin vdd w_n6_144# pfet w=22 l=2
+  ad=110 pd=54 as=0 ps=0
M1169 a_22_n244# P2_Not a_22_n205# w_9_n211# pfet w=40 l=2
+  ad=200 pd=90 as=0 ps=0
M1170 a_39_96# a_7_127# a_39_135# w_26_129# pfet w=40 l=2
+  ad=200 pd=90 as=0 ps=0
M1171 vdd C0 a_134_n213# w_121_n219# pfet w=20 l=2
+  ad=0 pd=0 as=0 ps=0
M1172 a_173_n125# C1_Inter_NOR gnd Gnd nfet w=20 l=2
+  ad=0 pd=0 as=0 ps=0
M1173 gnd C3_Inter_03 a_211_n494# Gnd nfet w=20 l=2
+  ad=0 pd=0 as=0 ps=0
M1174 a_224_35# C0 vdd w_211_53# pfet w=22 l=2
+  ad=110 pd=54 as=0 ps=0
M1175 a_151_n355# C3_Inter_NOR vdd w_138_n361# pfet w=20 l=2
+  ad=0 pd=0 as=0 ps=0
C0 B0 A0 1.61fF
C1 C1_Inter_NAND a_46_n176# 0.00fF
C2 a_7_127# G0_Not 0.03fF
C3 P0_Not gnd 0.17fF
C4 w_253_n383# C3_Inter_02 0.06fF
C5 w_138_n361# C3_Inter_NOR 0.06fF
C6 w_9_n211# P2_Not 0.06fF
C7 gnd Cin 0.06fF
C8 a_7_127# Inter_S1 0.04fF
C9 Cin a_237_103# 0.16fF
C10 gnd C0 1.19fF
C11 w_259_n148# vdd 0.03fF
C12 vdd a_73_n249# 0.01fF
C13 Inter_S0 S0 0.35fF
C14 gnd C1_Inter_NAND 0.19fF
C15 P2_Not G3_Not 0.15fF
C16 P0_Not G1_Not 0.05fF
C17 gnd P3_Not 0.48fF
C18 w_147_n442# C3_Inter_NOR 0.06fF
C19 w_67_n263# P2_Not 0.06fF
C20 w_n109_n294# vdd 0.02fF
C21 P1_Not C2_Inter_NOR 0.26fF
C22 C1_Inter_NAND G1_Not 0.03fF
C23 G0_Not P1_Not 0.10fF
C24 vdd a_46_n316# 0.12fF
C25 vdd C1_Inter_NOR 0.24fF
C26 gnd a_48_n36# 0.95fF
C27 Inter_S2 G2_Not 0.10fF
C28 C1_Inter_01 a_248_n65# 0.03fF
C29 w_121_n219# C0 0.06fF
C30 w_n110_87# P0_Not 0.02fF
C31 Cin a_173_n86# 0.02fF
C32 w_211_53# vdd 0.03fF
C33 w_31_49# G0_Not 0.06fF
C34 G1_Not a_n99_n99# 0.01fF
C35 w_9_n351# C3_Inter_NAND 0.15fF
C36 A1 P1_Not 0.03fF
C37 w_206_n317# C3_Inter_01 0.06fF
C38 P3_Not a_22_n384# 0.20fF
C39 w_n162_127# A0 0.06fF
C40 w_224_121# a_237_103# 0.02fF
C41 w_31_49# C0_Inter_01 0.06fF
C42 a_22_n205# G2_Not 0.01fF
C43 G1_Not a_48_n36# 0.24fF
C44 vdd Inter_S2 0.16fF
C45 w_211_53# a_224_35# 0.02fF
C46 w_n162_12# a_n149_18# 0.02fF
C47 a_7_127# a_211_n494# 0.03fF
C48 w_n160_n577# Inter_S3 0.03fF
C49 w_235_n32# C1_Inter_NAND 0.06fF
C50 P1_Not a_24_n104# 0.20fF
C51 w_259_n148# Inter_S2 0.26fF
C52 P2_Not C2_Inter_NOR 0.02fF
C53 P3_Not A3 0.03fF
C54 gnd B2 0.06fF
C55 w_67_n403# P3_Not 0.06fF
C56 w_9_n351# G3_Not 0.09fF
C57 w_9_n211# C2_Inter_NAND 0.15fF
C58 w_210_n204# C2_Inter_01 0.06fF
C59 C1_Inter_NAND G2_Not 0.00fF
C60 P0_Not vdd 0.16fF
C61 B0 gnd 0.06fF
C62 A0 G0_Not 0.50fF
C63 w_n160_n462# G3_Not 0.15fF
C64 w_n109_n294# Inter_S2 0.48fF
C65 P0_Not a_39_96# 0.03fF
C66 vdd Cin 0.10fF
C67 w_n161_n254# G2_Not 0.15fF
C68 w_9_n211# a_46_n176# 0.10fF
C69 vdd C0 0.08fF
C70 gnd Inter_S0 0.34fF
C71 G2_Not P3_Not 0.20fF
C72 w_69_n123# vdd 0.19fF
C73 w_11_n71# G0_Not 0.06fF
C74 C1_Inter_NOR Inter_S2 0.03fF
C75 C1 a_272_n166# 0.17fF
C76 gnd a_134_n213# 0.02fF
C77 vdd C1_Inter_NAND 0.08fF
C78 a_237_103# Inter_S0 0.17fF
C79 gnd C3_Inter_NAND 0.09fF
C80 w_253_n383# C3_Inter_04 0.06fF
C81 C0 a_224_35# 0.16fF
C82 P2_Not a_22_n345# 0.01fF
C83 P1_Not a_22_n244# 0.02fF
C84 P2_Not C3_Inter_NOR 0.26fF
C85 w_n161_n254# vdd 0.09fF
C86 vdd P3_Not 0.06fF
C87 C3_Inter_01 C3_Inter_NAND 0.25fF
C88 w_n108_n502# B3 0.06fF
C89 a_7_127# P1_Not 0.05fF
C90 P0_Not a_24_n65# 0.01fF
C91 C2_Inter_01 C2_Inter_NAND 0.36fF
C92 gnd G3_Not 0.12fF
C93 B3 Inter_S3 0.35fF
C94 vdd a_48_n36# 0.12fF
C95 P0_Not C1_Inter_NOR 0.26fF
C96 Cin C1_Inter_NOR 0.31fF
C97 w_9_n211# G1_Not 0.06fF
C98 w_11_n71# a_24_n104# 0.09fF
C99 w_206_n317# vdd 0.08fF
C100 C0 C1_Inter_NOR 0.07fF
C101 w_69_n123# C1_Inter_NOR 0.06fF
C102 w_n110_87# B0 0.06fF
C103 vdd a_73_n389# 0.01fF
C104 gnd a_151_n355# 0.02fF
C105 C1_Inter_NAND C1_Inter_NOR 0.15fF
C106 w_121_n219# a_134_n213# 0.22fF
C107 w_224_121# vdd 0.02fF
C108 w_n162_12# A0 0.26fF
C109 w_n160_n577# a_n147_n571# 0.02fF
C110 gnd C3_Inter_03 0.02fF
C111 w_26_129# C0_Inter_01 0.05fF
C112 P2_Not a_22_n244# 0.20fF
C113 Inter_S1 a_n151_n174# 0.05fF
C114 C3_Inter_01 a_151_n355# 0.05fF
C115 w_n164_n180# a_n151_n174# 0.02fF
C116 w_211_53# C0 0.26fF
C117 G2_Not B2 0.26fF
C118 gnd C2_Inter_01 0.02fF
C119 C0 Inter_S2 0.04fF
C120 w_n161_n369# a_n148_n363# 0.02fF
C121 a_22_n384# G3_Not 0.01fF
C122 C1_Inter_NAND Inter_S2 0.11fF
C123 A1 a_n151_n174# 0.16fF
C124 a_7_127# P2_Not 0.08fF
C125 w_n164_n65# G1_Not 0.15fF
C126 G3_Not A3 0.27fF
C127 gnd C2_Inter_NOR 0.40fF
C128 w_235_n32# a_248_n65# 0.09fF
C129 P0_Not Cin 0.05fF
C130 G0_Not gnd 0.02fF
C131 w_9_n211# G2_Not 0.09fF
C132 vdd Inter_S0 0.10fF
C133 gnd C0_Inter_01 0.06fF
C134 A0 a_n149_18# 0.16fF
C135 w_n112_n105# Inter_S1 0.48fF
C136 w_69_n123# P0_Not 0.06fF
C137 Cin C0 0.32fF
C138 gnd Inter_S1 0.23fF
C139 A2 a_n148_n363# 0.16fF
C140 vdd C3_Inter_NAND 0.13fF
C141 Cin C1_Inter_NAND 0.05fF
C142 w_121_n219# C2_Inter_01 0.02fF
C143 P1_Not P2_Not 0.03fF
C144 w_n160_n462# B3 0.06fF
C145 C0 C1_Inter_NAND 0.05fF
C146 Inter_S1 S1 0.35fF
C147 w_n109_n294# B2 0.06fF
C148 G2_Not G3_Not 0.05fF
C149 w_160_n92# C1_Inter_01 0.02fF
C150 w_n112_n105# A1 0.06fF
C151 w_9_n211# vdd 0.28fF
C152 C3_Inter_04 a_211_n494# 0.04fF
C153 gnd A1 0.26fF
C154 G0_Not G1_Not 0.06fF
C155 B3 a_n147_n571# 0.17fF
C156 Inter_S1 G1_Not 0.05fF
C157 w_210_n204# C2 0.02fF
C158 w_n161_n369# A2 0.26fF
C159 vdd G3_Not 0.19fF
C160 P0_Not a_48_n36# 0.07fF
C161 gnd C3_Inter_NOR 0.43fF
C162 w_n160_n577# A3 0.26fF
C163 w_198_n461# C3_Inter_03 0.06fF
C164 w_121_n219# C2_Inter_NOR 0.06fF
C165 w_11_n71# P1_Not 0.06fF
C166 w_67_n263# vdd 0.19fF
C167 A1 G1_Not 0.27fF
C168 Inter_S2 B2 0.86fF
C169 C1_Inter_NAND a_48_n36# 0.09fF
C170 vdd a_75_n109# 0.01fF
C171 C3_Inter_NAND a_46_n316# 0.09fF
C172 C1_Inter_NOR C3_Inter_NAND 0.04fF
C173 gnd B3 0.06fF
C174 w_n6_144# vdd 0.02fF
C175 w_26_129# a_7_127# 0.07fF
C176 w_253_n383# vdd 0.06fF
C177 w_n164_n65# vdd 0.09fF
C178 w_224_121# Cin 0.26fF
C179 G1_Not a_24_n104# 0.01fF
C180 w_n162_127# vdd 0.09fF
C181 P2_Not A2 0.03fF
C182 a_22_n244# a_46_n176# 0.05fF
C183 w_138_n361# C3_Inter_01 0.02fF
C184 G3_Not a_46_n316# 0.24fF
C185 w_n164_n65# B1 0.06fF
C186 w_n160_n577# vdd 0.02fF
C187 C3_Inter_02 C3_Inter_04 0.23fF
C188 B0 P0_Not 0.19fF
C189 vdd C2_Inter_NOR 0.13fF
C190 vdd G0_Not 0.10fF
C191 a_7_127# gnd 0.15fF
C192 C1_Inter_NOR C3_Inter_03 0.02fF
C193 w_67_n403# C3_Inter_NOR 0.06fF
C194 P0_Not Inter_S0 0.05fF
C195 vdd C0_Inter_01 0.07fF
C196 G1_Not a_22_n244# 0.02fF
C197 w_n161_n254# B2 0.06fF
C198 vdd Inter_S1 0.17fF
C199 gnd a_n149_18# 0.07fF
C200 a_39_96# C0_Inter_01 0.04fF
C201 Cin Inter_S0 0.23fF
C202 w_n164_n180# vdd 0.02fF
C203 B3 A3 1.61fF
C204 Inter_S0 C0 0.11fF
C205 w_253_n383# C3 0.15fF
C206 C0 a_134_n213# 0.02fF
C207 a_224_35# Inter_S1 0.17fF
C208 P1_Not a_46_n176# 0.07fF
C209 a_7_127# G1_Not 0.16fF
C210 C1_Inter_NAND C3_Inter_NAND 0.04fF
C211 gnd a_n148_n363# 0.07fF
C212 w_9_n351# P2_Not 0.17fF
C213 Inter_S1 B1 0.86fF
C214 w_n112_n105# P1_Not 0.02fF
C215 w_n164_n180# B1 0.40fF
C216 a_272_n166# S2 0.05fF
C217 gnd P1_Not 0.47fF
C218 C1_Inter_NOR C2_Inter_NOR 0.01fF
C219 vdd C3_Inter_NOR 0.19fF
C220 gnd C1 0.46fF
C221 B1 A1 1.61fF
C222 C1_Inter_NAND a_248_n65# 0.19fF
C223 C3_Inter_01 C3_Inter_02 0.03fF
C224 vdd B3 0.00fF
C225 w_198_n461# a_211_n494# 0.09fF
C226 a_n147_n571# Inter_S3 0.05fF
C227 w_138_n361# vdd 0.09fF
C228 w_n162_12# vdd 0.02fF
C229 w_n6_144# Cin 0.06fF
C230 G1_Not P1_Not 0.06fF
C231 w_206_n317# C3_Inter_NAND 0.06fF
C232 P3_Not G3_Not 0.00fF
C233 w_160_n92# a_173_n86# 0.22fF
C234 C1_Inter_NAND a_151_n355# 0.02fF
C235 a_22_n244# G2_Not 0.01fF
C236 w_224_121# Inter_S0 0.40fF
C237 w_211_53# Inter_S1 0.40fF
C238 w_259_n148# a_272_n166# 0.02fF
C239 C2_Inter_01 a_223_n237# 0.03fF
C240 a_7_127# G2_Not 0.13fF
C241 gnd P2_Not 0.58fF
C242 C1_Inter_NOR C3_Inter_NOR 0.30fF
C243 gnd Inter_S3 0.12fF
C244 w_147_n442# vdd 0.11fF
C245 w_198_n461# a_7_127# 0.06fF
C246 gnd A2 0.26fF
C247 w_210_n204# C2_Inter_NAND 0.06fF
C248 a_7_127# vdd 0.05fF
C249 P0_Not G0_Not 0.68fF
C250 A0 gnd 0.26fF
C251 w_235_n32# C1 0.02fF
C252 B0 Inter_S0 0.42fF
C253 a_7_127# a_39_96# 0.19fF
C254 C0 C2_Inter_NOR 0.26fF
C255 G1_Not P2_Not 0.32fF
C256 Cin C0_Inter_01 0.58fF
C257 P0_Not Inter_S1 0.05fF
C258 w_160_n92# vdd 0.09fF
C259 C1_Inter_NAND C2_Inter_NOR 0.01fF
C260 C1 S2 0.35fF
C261 Cin Inter_S1 0.05fF
C262 a_237_103# S0 0.05fF
C263 gnd C1_Inter_01 0.42fF
C264 C0_Inter_01 C0 0.02fF
C265 C0 Inter_S1 0.23fF
C266 P2_Not a_22_n384# 0.02fF
C267 P1_Not G2_Not 0.09fF
C268 w_147_n442# C1_Inter_NOR 0.06fF
C269 w_n108_n502# A3 0.06fF
C270 w_11_n71# G1_Not 0.09fF
C271 Inter_S2 a_272_n166# 0.16fF
C272 vdd P1_Not 0.13fF
C273 P0_Not a_24_n104# 0.02fF
C274 vdd C1 0.06fF
C275 w_67_n403# P2_Not 0.06fF
C276 w_n161_n369# vdd 0.02fF
C277 C3_Inter_NAND G3_Not 0.03fF
C278 w_259_n148# C1 0.55fF
C279 w_160_n92# C1_Inter_NOR 0.06fF
C280 C1_Inter_NAND C3_Inter_NOR 0.31fF
C281 C2_Inter_NAND a_46_n176# 0.09fF
C282 gnd C3_Inter_04 0.46fF
C283 w_n110_87# A0 0.06fF
C284 gnd a_n151_n174# 0.07fF
C285 w_31_49# vdd 0.07fF
C286 B1 P1_Not 0.19fF
C287 w_n162_127# B0 0.06fF
C288 P2_Not G2_Not 0.15fF
C289 C1_Inter_01 a_173_n86# 0.05fF
C290 a_7_127# Inter_S2 0.06fF
C291 P3_Not C3_Inter_NOR 0.02fF
C292 G2_Not A2 0.27fF
C293 gnd C2_Inter_NAND 0.09fF
C294 w_138_n361# C1_Inter_NAND 0.06fF
C295 w_235_n32# C1_Inter_01 0.06fF
C296 w_n108_n502# vdd 0.21fF
C297 gnd a_n147_n571# 0.07fF
C298 C2_Inter_01 a_134_n213# 0.05fF
C299 P1_Not C1_Inter_NOR 0.02fF
C300 a_24_n104# a_48_n36# 0.05fF
C301 vdd P2_Not 0.08fF
C302 P3_Not B3 0.19fF
C303 gnd a_46_n176# 0.95fF
C304 w_9_n351# a_22_n384# 0.09fF
C305 Inter_S2 a_n148_n363# 0.05fF
C306 C3_Inter_02 C3 0.02fF
C307 B0 G0_Not 0.49fF
C308 P0_Not a_7_127# 0.45fF
C309 a_7_127# Cin 0.08fF
C310 P1_Not Inter_S2 0.06fF
C311 G0_Not Inter_S0 0.05fF
C312 gnd a_237_103# 0.05fF
C313 w_11_n71# vdd 0.23fF
C314 C1 Inter_S2 0.12fF
C315 w_160_n92# Cin 0.06fF
C316 gnd C3_Inter_01 0.19fF
C317 Inter_S0 Inter_S1 0.40fF
C318 w_n161_n369# Inter_S2 0.02fF
C319 w_n109_n294# P2_Not 0.02fF
C320 P1_Not a_22_n205# 0.01fF
C321 w_n160_n462# A3 0.06fF
C322 w_n109_n294# A2 0.06fF
C323 w_n112_n105# G1_Not 0.01fF
C324 P2_Not a_46_n316# 0.07fF
C325 a_223_n237# C2 0.04fF
C326 w_210_n204# vdd 0.12fF
C327 a_7_127# P3_Not 0.04fF
C328 gnd G1_Not 0.14fF
C329 A3 a_n147_n571# 0.16fF
C330 w_9_n351# G2_Not 0.06fF
C331 P0_Not P1_Not 0.03fF
C332 w_198_n461# C3_Inter_04 0.02fF
C333 w_67_n263# C2_Inter_NOR 0.06fF
C334 w_69_n123# P1_Not 0.06fF
C335 w_9_n351# vdd 0.28fF
C336 Inter_S2 A2 0.06fF
C337 C2_Inter_NAND G2_Not 0.03fF
C338 gnd a_173_n86# 0.02fF
C339 gnd A3 0.26fF
C340 w_26_129# vdd 0.11fF
C341 w_n162_12# B0 0.40fF
C342 w_n160_n462# vdd 0.09fF
C343 w_235_n32# gnd 0.03fF
C344 w_26_129# a_39_96# 0.09fF
C345 w_n162_127# G0_Not 0.15fF
C346 w_31_49# C0 0.15fF
C347 w_n162_12# Inter_S0 0.06fF
C348 G2_Not a_46_n176# 0.24fF
C349 vdd C2_Inter_NAND 0.13fF
C350 a_22_n345# G3_Not 0.01fF
C351 B1 a_n151_n174# 0.17fF
C352 vdd a_46_n176# 0.12fF
C353 gnd G2_Not 0.14fF
C354 w_n164_n65# A1 0.06fF
C355 w_206_n317# C3_Inter_02 0.02fF
C356 w_9_n351# a_46_n316# 0.10fF
C357 G3_Not B3 0.26fF
C358 A0 P0_Not 0.03fF
C359 w_n112_n105# vdd 0.02fF
C360 w_n108_n502# P3_Not 0.02fF
C361 vdd gnd 2.09fF
C362 w_9_n211# a_22_n244# 0.09fF
C363 a_7_127# Inter_S0 0.04fF
C364 G0_Not C0_Inter_01 0.32fF
C365 B0 a_n149_18# 0.17fF
C366 P2_Not P3_Not 0.03fF
C367 w_11_n71# P0_Not 0.17fF
C368 G1_Not G2_Not 0.06fF
C369 w_n161_n254# A2 0.06fF
C370 B2 a_n148_n363# 0.17fF
C371 G0_Not Inter_S1 0.05fF
C372 gnd a_224_35# 0.07fF
C373 C1_Inter_NOR C2_Inter_NAND 0.05fF
C374 w_138_n361# a_151_n355# 0.22fF
C375 Inter_S0 a_n149_18# 0.05fF
C376 a_224_35# S1 0.05fF
C377 G2_Not a_22_n384# 0.02fF
C378 w_11_n71# C1_Inter_NAND 0.15fF
C379 w_n164_n180# Inter_S1 0.02fF
C380 w_n112_n105# B1 0.06fF
C381 C1_Inter_01 C1_Inter_NAND 0.22fF
C382 vdd G1_Not 0.22fF
C383 gnd B1 0.06fF
C384 C3_Inter_03 a_211_n494# 0.19fF
C385 Inter_S1 A1 0.06fF
C386 w_n161_n369# B2 0.40fF
C387 w_210_n204# a_223_n237# 0.09fF
C388 w_n164_n180# A1 0.26fF
C389 a_7_127# G3_Not 0.03fF
C390 G0_Not a_24_n104# 0.02fF
C391 w_147_n442# C3_Inter_03 0.15fF
C392 gnd a_46_n316# 0.95fF
C393 w_n160_n577# B3 0.40fF
C394 gnd C1_Inter_NOR 0.54fF
C395 w_121_n219# vdd 0.09fF
C396 B1 G1_Not 0.29fF
C397 w_11_n71# a_48_n36# 0.10fF
C398 C3_Inter_NAND C3_Inter_02 0.19fF
C399 w_n6_144# a_7_127# 0.02fF
C400 w_n110_87# vdd 0.02fF
C401 w_26_129# P0_Not 0.06fF
C402 a_7_127# C3_Inter_03 0.28fF
C403 vdd A3 0.00fF
C404 w_9_n211# P1_Not 0.17fF
C405 w_67_n403# vdd 0.19fF
C406 w_235_n32# vdd 0.12fF
C407 G1_Not a_24_n65# 0.01fF
C408 w_224_121# S0 0.02fF
C409 P2_Not B2 0.19fF
C410 gnd Inter_S2 0.18fF
C411 w_211_53# S1 0.02fF
C412 B2 A2 1.61fF
C413 w_9_n351# P3_Not 0.06fF
C414 C0 C2_Inter_NAND 0.05fF
C415 a_22_n384# a_46_n316# 0.05fF
C416 w_259_n148# S2 0.02fF
C417 C2_Inter_NAND a_223_n237# 0.19fF
C418 C1_Inter_NAND C2_Inter_NAND 0.11fF
C419 a_248_n65# C1 0.04fF
C420 vdd G2_Not 0.15fF
C421 w_67_n263# P1_Not 0.06fF
C422 w_198_n461# vdd 0.11fF
C423 w_121_n219# C1_Inter_NOR 0.03fF
C424 G1_Not Inter_S2 0.06fF
C425 Inter_S3 Gnd 0.08fF
C426 a_n147_n571# Gnd 0.61fF
C427 a_211_n494# Gnd 0.17fF
C428 C3_Inter_03 Gnd 0.09fF
C429 A3 Gnd 0.99fF
C430 B3 Gnd 0.42fF
C431 C3 Gnd 0.19fF
C432 C3_Inter_04 Gnd 0.44fF
C433 a_151_n355# Gnd 0.29fF
C434 C3_Inter_NOR Gnd 0.95fF
C435 a_46_n316# Gnd 0.34fF
C436 C3_Inter_02 Gnd 0.48fF
C437 G3_Not Gnd 0.12fF
C438 a_22_n384# Gnd 0.17fF
C439 a_n148_n363# Gnd 0.61fF
C440 P3_Not Gnd 0.03fF
C441 C3_Inter_NAND Gnd 2.00fF
C442 C3_Inter_01 Gnd 0.38fF
C443 C2 Gnd 0.02fF
C444 a_223_n237# Gnd 0.17fF
C445 a_134_n213# Gnd 0.29fF
C446 C2_Inter_NOR Gnd 0.38fF
C447 A2 Gnd 0.99fF
C448 B2 Gnd 0.42fF
C449 a_46_n176# Gnd 0.34fF
C450 G2_Not Gnd 0.12fF
C451 a_22_n244# Gnd 0.17fF
C452 P2_Not Gnd 2.82fF
C453 C2_Inter_NAND Gnd 2.25fF
C454 C2_Inter_01 Gnd 0.36fF
C455 S2 Gnd 0.06fF
C456 a_272_n166# Gnd 0.61fF
C457 Inter_S2 Gnd 2.08fF
C458 a_n151_n174# Gnd 0.61fF
C459 a_173_n86# Gnd 0.43fF
C460 C1_Inter_NOR Gnd 2.56fF
C461 C1 Gnd 1.46fF
C462 a_48_n36# Gnd 0.34fF
C463 a_248_n65# Gnd 0.17fF
C464 a_24_n104# Gnd 0.17fF
C465 P1_Not Gnd 2.74fF
C466 G1_Not Gnd 0.12fF
C467 A1 Gnd 0.99fF
C468 B1 Gnd 0.42fF
C469 C1_Inter_NAND Gnd 2.95fF
C470 C1_Inter_01 Gnd 0.44fF
C471 S1 Gnd 0.06fF
C472 Inter_S1 Gnd 4.39fF
C473 a_224_35# Gnd 0.61fF
C474 a_n149_18# Gnd 0.61fF
C475 C0 Gnd 0.09fF
C476 S0 Gnd 0.04fF
C477 Inter_S0 Gnd 4.34fF
C478 a_237_103# Gnd 0.61fF
C479 C0_Inter_01 Gnd 0.11fF
C480 a_39_96# Gnd 0.04fF
C481 Cin Gnd 1.21fF
C482 gnd Gnd 15.15fF
C483 G0_Not Gnd 3.97fF
C484 vdd Gnd 12.61fF
C485 a_7_127# Gnd 4.69fF
C486 P0_Not Gnd 4.11fF
C487 A0 Gnd 0.92fF
C488 B0 Gnd 1.13fF
C489 w_n160_n577# Gnd 1.44fF
C490 w_198_n461# Gnd 2.34fF
C491 w_147_n442# Gnd 1.09fF
C492 w_n108_n502# Gnd 3.14fF
C493 w_n160_n462# Gnd 1.31fF
C494 w_253_n383# Gnd 1.09fF
C495 w_67_n403# Gnd 0.82fF
C496 w_138_n361# Gnd 1.69fF
C497 w_n161_n369# Gnd 1.44fF
C498 w_206_n317# Gnd 1.78fF
C499 w_9_n351# Gnd 0.37fF
C500 w_67_n263# Gnd 0.82fF
C501 w_121_n219# Gnd 1.69fF
C502 w_n109_n294# Gnd 3.14fF
C503 w_n161_n254# Gnd 1.31fF
C504 w_210_n204# Gnd 2.34fF
C505 w_9_n211# Gnd 0.08fF
C506 w_n164_n180# Gnd 1.44fF
C507 w_259_n148# Gnd 1.44fF
C508 w_160_n92# Gnd 1.69fF
C509 w_69_n123# Gnd 0.82fF
C510 w_11_n71# Gnd 0.37fF
C511 w_n112_n105# Gnd 3.14fF
C512 w_n164_n65# Gnd 1.31fF
C513 w_235_n32# Gnd 2.34fF
C514 w_n162_12# Gnd 1.44fF
C515 w_211_53# Gnd 1.44fF
C516 w_31_49# Gnd 1.09fF
C517 w_224_121# Gnd 1.44fF
C518 w_26_129# Gnd 2.34fF
C519 w_n6_144# Gnd 0.82fF
C520 w_n110_87# Gnd 0.90fF
C521 w_n162_127# Gnd 0.37fF
