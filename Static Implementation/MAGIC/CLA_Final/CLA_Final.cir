* Extracted Netlist
.include TSMC_180nm.txt
.param SUPPLY=1.8
.global gnd vdd

* Supply
Vdd vdd gnd 'SUPPLY'

* SPICE3 file created from CLA_Final.ext - technology: scmos

.option scale=0.09u

M1000 vdd Cin a_173_n86# w_160_n92# CMOSP w=20 l=2
+  ad=8870 pd=4142 as=160 ps=56
M1001 gnd B2 P2_Not Gnd CMOSN w=40 l=2
+  ad=6071 pd=3066 as=320 ps=96
M1002 C0_Inter_01 a_39_96# vdd w_26_129# CMOSP w=22 l=2
+  ad=110 pd=54 as=0 ps=0
M1003 Inter_S3 B3 A3 w_n160_n577# CMOSP w=10 l=2
+  ad=110 pd=62 as=50 ps=30
M1004 G3_Not A3 a_n147_n515# Gnd CMOSN w=40 l=2
+  ad=240 pd=92 as=320 ps=96
M1005 C2_Inter_01 a_134_n213# vdd w_121_n219# CMOSP w=22 l=2
+  ad=110 pd=54 as=0 ps=0
M1006 a_88_n314# a_46_n316# gnd Gnd CMOSN w=20 l=2
+  ad=160 pd=56 as=0 ps=0
M1007 gnd P1_Not a_24_n104# Gnd CMOSN w=20 l=2
+  ad=0 pd=0 as=160 ps=56
M1008 Inter_S3 B3 a_n147_n571# Gnd CMOSN w=5 l=2
+  ad=30 pd=22 as=90 ps=56
M1009 Inter_S0 Cin S0 w_224_121# CMOSP w=10 l=2
+  ad=120 pd=64 as=60 ps=32
M1010 C1_Inter_NAND G1_Not a_90_n34# Gnd CMOSN w=20 l=2
+  ad=120 pd=52 as=160 ps=56
M1011 C1 a_248_n65# vdd w_235_n32# CMOSP w=22 l=2
+  ad=170 pd=86 as=0 ps=0
M1012 a_46_n316# a_22_n384# vdd w_9_n351# CMOSP w=22 l=2
+  ad=110 pd=54 as=0 ps=0
M1013 a_7_127# Cin gnd Gnd CMOSN w=11 l=2
+  ad=55 pd=32 as=0 ps=0
M1014 gnd P0_Not C1_Inter_NOR Gnd CMOSN w=5 l=2
+  ad=0 pd=0 as=40 ps=26
M1015 C3_Inter_NOR P3_Not gnd Gnd CMOSN w=5 l=2
+  ad=40 pd=26 as=0 ps=0
M1016 B0 A0 Inter_S0 w_n162_12# CMOSP w=10 l=2
+  ad=60 pd=32 as=0 ps=0
M1017 a_24_n104# P1_Not a_24_n65# w_11_n71# CMOSP w=40 l=2
+  ad=200 pd=90 as=320 ps=96
M1018 G0_Not B0 vdd w_n162_127# CMOSP w=40 l=2
+  ad=320 pd=96 as=0 ps=0
M1019 vdd C1_Inter_NOR C3_Inter_03 w_147_n442# CMOSP w=20 l=2
+  ad=0 pd=0 as=160 ps=56
M1020 gnd C3_Inter_NAND C3_Inter_02 Gnd CMOSN w=20 l=2
+  ad=0 pd=0 as=160 ps=56
M1021 Inter_S0 B0 a_n149_18# Gnd CMOSN w=5 l=2
+  ad=60 pd=44 as=90 ps=56
M1022 gnd P3_Not a_22_n384# Gnd CMOSN w=20 l=2
+  ad=0 pd=0 as=160 ps=56
M1023 C2_Inter_NOR P1_Not a_73_n249# w_67_n263# CMOSP w=10 l=2
+  ad=50 pd=30 as=80 ps=36
M1024 a_46_n176# a_22_n244# gnd Gnd CMOSN w=11 l=2
+  ad=55 pd=32 as=0 ps=0
M1025 P1_Not A1 gnd Gnd CMOSN w=40 l=2
+  ad=320 pd=96 as=0 ps=0
M1026 C2 Inter_S3 S3 w_270_n264# CMOSP w=10 l=2
+  ad=170 pd=86 as=60 ps=32
M1027 a_266_n416# C3_Inter_04 gnd Gnd CMOSN w=20 l=2
+  ad=160 pd=56 as=0 ps=0
M1028 S1 Inter_S1 C0 w_211_53# CMOSP w=10 l=2
+  ad=60 pd=32 as=210 ps=86
M1029 a_151_n355# C1_Inter_NAND a_151_n394# Gnd CMOSN w=20 l=2
+  ad=120 pd=52 as=160 ps=56
M1030 a_223_n237# C2_Inter_01 gnd Gnd CMOSN w=20 l=2
+  ad=160 pd=56 as=0 ps=0
M1031 C1 a_272_n166# S2 Gnd CMOSN w=5 l=2
+  ad=85 pd=54 as=30 ps=22
M1032 a_224_35# C0 gnd Gnd CMOSN w=11 l=2
+  ad=90 pd=56 as=0 ps=0
M1033 a_272_n166# Inter_S2 vdd w_259_n148# CMOSP w=22 l=2
+  ad=110 pd=54 as=0 ps=0
M1034 P2_Not B2 a_n96_n288# w_n109_n294# CMOSP w=80 l=2
+  ad=400 pd=170 as=640 ps=176
M1035 vdd A3 G3_Not w_n160_n462# CMOSP w=40 l=2
+  ad=0 pd=0 as=320 ps=96
M1036 a_22_n205# G1_Not vdd w_9_n211# CMOSP w=40 l=2
+  ad=320 pd=96 as=0 ps=0
M1037 a_134_n213# C2_Inter_NOR vdd w_121_n219# CMOSP w=20 l=2
+  ad=160 pd=56 as=0 ps=0
M1038 a_248_n65# C1_Inter_NAND a_248_n26# w_235_n32# CMOSP w=40 l=2
+  ad=200 pd=90 as=320 ps=96
M1039 a_211_n494# a_7_127# gnd Gnd CMOSN w=20 l=2
+  ad=160 pd=56 as=0 ps=0
M1040 Inter_S2 B2 A2 w_n161_n369# CMOSP w=10 l=2
+  ad=110 pd=62 as=50 ps=30
M1041 P0_Not A0 gnd Gnd CMOSN w=40 l=2
+  ad=320 pd=96 as=0 ps=0
M1042 a_n148_n307# B2 gnd Gnd CMOSN w=40 l=2
+  ad=320 pd=96 as=0 ps=0
M1043 Inter_S2 B2 a_n148_n363# Gnd CMOSN w=5 l=2
+  ad=30 pd=22 as=90 ps=56
M1044 a_88_n174# a_46_n176# gnd Gnd CMOSN w=20 l=2
+  ad=160 pd=56 as=0 ps=0
M1045 a_39_135# P0_Not vdd w_26_129# CMOSP w=40 l=2
+  ad=320 pd=96 as=0 ps=0
M1046 a_24_n104# G0_Not gnd Gnd CMOSN w=20 l=2
+  ad=0 pd=0 as=0 ps=0
M1047 P3_Not A3 gnd Gnd CMOSN w=40 l=2
+  ad=320 pd=96 as=0 ps=0
M1048 a_n148_n363# A2 vdd w_n161_n369# CMOSP w=22 l=2
+  ad=110 pd=54 as=0 ps=0
M1049 C1_Inter_01 a_173_n86# vdd w_160_n92# CMOSP w=22 l=2
+  ad=110 pd=54 as=0 ps=0
M1050 a_173_n86# C1_Inter_NOR vdd w_160_n92# CMOSP w=20 l=2
+  ad=0 pd=0 as=0 ps=0
M1051 gnd B1 P1_Not Gnd CMOSN w=40 l=2
+  ad=0 pd=0 as=0 ps=0
M1052 a_n148_n363# A2 gnd Gnd CMOSN w=11 l=2
+  ad=0 pd=0 as=0 ps=0
M1053 S0 Inter_S0 a_237_103# Gnd CMOSN w=5 l=2
+  ad=30 pd=22 as=90 ps=56
M1054 a_46_n176# a_22_n244# vdd w_9_n211# CMOSP w=22 l=2
+  ad=110 pd=54 as=0 ps=0
M1055 C3_Inter_03 C3_Inter_NOR vdd w_147_n442# CMOSP w=20 l=2
+  ad=0 pd=0 as=0 ps=0
M1056 C3_Inter_02 C3_Inter_01 gnd Gnd CMOSN w=20 l=2
+  ad=0 pd=0 as=0 ps=0
M1057 a_237_103# Cin vdd w_224_121# CMOSP w=22 l=2
+  ad=110 pd=54 as=0 ps=0
M1058 a_n99_n99# A1 vdd w_n112_n105# CMOSP w=80 l=2
+  ad=640 pd=176 as=0 ps=0
M1059 a_22_n384# G2_Not gnd Gnd CMOSN w=20 l=2
+  ad=0 pd=0 as=0 ps=0
M1060 C2_Inter_NOR P2_Not gnd Gnd CMOSN w=5 l=2
+  ad=40 pd=26 as=0 ps=0
M1061 gnd a_7_127# a_39_96# Gnd CMOSN w=20 l=2
+  ad=0 pd=0 as=160 ps=56
M1062 C3_Inter_NAND G3_Not a_88_n314# Gnd CMOSN w=20 l=2
+  ad=120 pd=52 as=0 ps=0
M1063 C1_Inter_NAND a_48_n36# vdd w_11_n71# CMOSP w=20 l=2
+  ad=160 pd=56 as=0 ps=0
M1064 a_134_n213# C0 a_134_n252# Gnd CMOSN w=20 l=2
+  ad=120 pd=52 as=160 ps=56
M1065 gnd P2_Not a_22_n244# Gnd CMOSN w=20 l=2
+  ad=0 pd=0 as=160 ps=56
M1066 gnd P2_Not C3_Inter_NOR Gnd CMOSN w=5 l=2
+  ad=0 pd=0 as=0 ps=0
M1067 vdd A0 G0_Not w_n162_127# CMOSP w=40 l=2
+  ad=0 pd=0 as=0 ps=0
M1068 a_n97_93# A0 vdd w_n110_87# CMOSP w=80 l=2
+  ad=640 pd=176 as=0 ps=0
M1069 a_24_n65# G0_Not vdd w_11_n71# CMOSP w=40 l=2
+  ad=0 pd=0 as=0 ps=0
M1070 C3_Inter_NAND a_46_n316# vdd w_9_n351# CMOSP w=20 l=2
+  ad=160 pd=56 as=0 ps=0
M1071 S1 Inter_S1 a_224_35# Gnd CMOSN w=5 l=2
+  ad=30 pd=22 as=0 ps=0
M1072 a_151_n394# C3_Inter_NOR gnd Gnd CMOSN w=20 l=2
+  ad=0 pd=0 as=0 ps=0
M1073 a_n149_18# A0 gnd Gnd CMOSN w=11 l=2
+  ad=0 pd=0 as=0 ps=0
M1074 S2 C1 Inter_S2 w_259_n148# CMOSP w=10 l=2
+  ad=60 pd=32 as=0 ps=0
M1075 C2 a_223_n237# gnd Gnd CMOSN w=11 l=2
+  ad=85 pd=54 as=0 ps=0
M1076 vdd C0_Inter_01 C0 w_31_49# CMOSP w=20 l=2
+  ad=0 pd=0 as=0 ps=0
M1077 a_48_n36# a_24_n104# gnd Gnd CMOSN w=11 l=2
+  ad=55 pd=32 as=0 ps=0
M1078 B3 A3 Inter_S3 w_n160_n577# CMOSP w=10 l=2
+  ad=60 pd=32 as=0 ps=0
M1079 G2_Not B2 vdd w_n161_n254# CMOSP w=40 l=2
+  ad=320 pd=96 as=0 ps=0
M1080 B3 a_n147_n571# Inter_S3 Gnd CMOSN w=5 l=2
+  ad=30 pd=22 as=0 ps=0
M1081 B1 A1 Inter_S1 w_n164_n180# CMOSP w=10 l=2
+  ad=60 pd=32 as=120 ps=64
M1082 vdd C3_Inter_02 C3 w_253_n383# CMOSP w=20 l=2
+  ad=0 pd=0 as=160 ps=56
M1083 a_283_n282# Inter_S3 vdd w_270_n264# CMOSP w=22 l=2
+  ad=110 pd=54 as=0 ps=0
M1084 a_75_n109# P1_Not vdd w_69_n123# CMOSP w=10 l=2
+  ad=80 pd=36 as=0 ps=0
M1085 B1 a_n151_n174# Inter_S1 Gnd CMOSN w=5 l=2
+  ad=30 pd=22 as=60 ps=44
M1086 C3_Inter_02 C3_Inter_NAND a_219_n311# w_206_n317# CMOSP w=40 l=2
+  ad=200 pd=90 as=320 ps=96
M1087 a_223_n237# C2_Inter_NAND a_223_n198# w_210_n204# CMOSP w=40 l=2
+  ad=200 pd=90 as=320 ps=96
M1088 Inter_S0 B0 A0 w_n162_12# CMOSP w=10 l=2
+  ad=0 pd=0 as=50 ps=30
M1089 a_n95_n496# A3 vdd w_n108_n502# CMOSP w=80 l=2
+  ad=640 pd=176 as=0 ps=0
M1090 a_n149_74# B0 gnd Gnd CMOSN w=40 l=2
+  ad=320 pd=96 as=0 ps=0
M1091 C3_Inter_04 a_211_n494# gnd Gnd CMOSN w=11 l=2
+  ad=55 pd=32 as=0 ps=0
M1092 C3_Inter_03 C1_Inter_NOR a_160_n475# Gnd CMOSN w=20 l=2
+  ad=120 pd=52 as=160 ps=56
M1093 G2_Not A2 a_n148_n307# Gnd CMOSN w=40 l=2
+  ad=240 pd=92 as=0 ps=0
M1094 a_237_103# Cin gnd Gnd CMOSN w=11 l=2
+  ad=0 pd=0 as=0 ps=0
M1095 gnd B0 P0_Not Gnd CMOSN w=40 l=2
+  ad=0 pd=0 as=0 ps=0
M1096 C2_Inter_01 a_134_n213# gnd Gnd CMOSN w=11 l=2
+  ad=55 pd=32 as=0 ps=0
M1097 a_73_n389# P3_Not vdd w_67_n403# CMOSP w=10 l=2
+  ad=80 pd=36 as=0 ps=0
M1098 S3 C2 Inter_S3 w_270_n264# CMOSP w=10 l=2
+  ad=0 pd=0 as=0 ps=0
M1099 C2 a_283_n282# S3 Gnd CMOSN w=5 l=2
+  ad=0 pd=0 as=30 ps=22
M1100 Inter_S0 a_237_103# S0 Gnd CMOSN w=5 l=2
+  ad=0 pd=0 as=0 ps=0
M1101 a_248_n26# C1_Inter_01 vdd w_235_n32# CMOSP w=40 l=2
+  ad=0 pd=0 as=0 ps=0
M1102 gnd B3 P3_Not Gnd CMOSN w=40 l=2
+  ad=0 pd=0 as=0 ps=0
M1103 a_n151_n118# B1 gnd Gnd CMOSN w=40 l=2
+  ad=320 pd=96 as=0 ps=0
M1104 C3_Inter_01 a_151_n355# vdd w_138_n361# CMOSP w=22 l=2
+  ad=110 pd=54 as=0 ps=0
M1105 G1_Not B1 vdd w_n164_n65# CMOSP w=40 l=2
+  ad=320 pd=96 as=0 ps=0
M1106 C2_Inter_NAND G2_Not a_88_n174# Gnd CMOSN w=20 l=2
+  ad=120 pd=52 as=0 ps=0
M1107 Inter_S1 C0 S1 w_211_53# CMOSP w=10 l=2
+  ad=0 pd=0 as=0 ps=0
M1108 C1 a_248_n65# gnd Gnd CMOSN w=11 l=2
+  ad=0 pd=0 as=0 ps=0
M1109 a_39_96# P0_Not gnd Gnd CMOSN w=20 l=2
+  ad=0 pd=0 as=0 ps=0
M1110 a_n151_n174# A1 vdd w_n164_n180# CMOSP w=22 l=2
+  ad=110 pd=54 as=0 ps=0
M1111 C2_Inter_NAND a_46_n176# vdd w_9_n211# CMOSP w=20 l=2
+  ad=160 pd=56 as=0 ps=0
M1112 a_211_n494# C3_Inter_03 a_211_n455# w_198_n461# CMOSP w=40 l=2
+  ad=200 pd=90 as=320 ps=96
M1113 a_22_n244# G1_Not gnd Gnd CMOSN w=20 l=2
+  ad=0 pd=0 as=0 ps=0
M1114 a_134_n252# C2_Inter_NOR gnd Gnd CMOSN w=20 l=2
+  ad=0 pd=0 as=0 ps=0
M1115 a_n151_n174# A1 gnd Gnd CMOSN w=11 l=2
+  ad=90 pd=56 as=0 ps=0
M1116 P0_Not B0 a_n97_93# w_n110_87# CMOSP w=80 l=2
+  ad=400 pd=170 as=0 ps=0
M1117 a_48_n36# a_24_n104# vdd w_11_n71# CMOSP w=22 l=2
+  ad=110 pd=54 as=0 ps=0
M1118 gnd C1_Inter_NAND a_248_n65# Gnd CMOSN w=20 l=2
+  ad=0 pd=0 as=160 ps=56
M1119 C1_Inter_01 a_173_n86# gnd Gnd CMOSN w=11 l=2
+  ad=55 pd=32 as=0 ps=0
M1120 gnd P1_Not C2_Inter_NOR Gnd CMOSN w=5 l=2
+  ad=0 pd=0 as=0 ps=0
M1121 a_272_n166# Inter_S2 gnd Gnd CMOSN w=11 l=2
+  ad=90 pd=56 as=0 ps=0
M1122 vdd A2 G2_Not w_n161_n254# CMOSP w=40 l=2
+  ad=0 pd=0 as=0 ps=0
M1123 C0 C0_Inter_01 a_44_16# Gnd CMOSN w=20 l=2
+  ad=120 pd=52 as=160 ps=56
M1124 vdd G1_Not C1_Inter_NAND w_11_n71# CMOSP w=20 l=2
+  ad=0 pd=0 as=0 ps=0
M1125 C0 G0_Not vdd w_31_49# CMOSP w=20 l=2
+  ad=0 pd=0 as=0 ps=0
M1126 a_283_n282# Inter_S3 gnd Gnd CMOSN w=11 l=2
+  ad=90 pd=56 as=0 ps=0
M1127 C3 C3_Inter_04 vdd w_253_n383# CMOSP w=20 l=2
+  ad=0 pd=0 as=0 ps=0
M1128 C3_Inter_04 a_211_n494# vdd w_198_n461# CMOSP w=22 l=2
+  ad=110 pd=54 as=0 ps=0
M1129 a_219_n311# C3_Inter_01 vdd w_206_n317# CMOSP w=40 l=2
+  ad=0 pd=0 as=0 ps=0
M1130 vdd G3_Not C3_Inter_NAND w_9_n351# CMOSP w=20 l=2
+  ad=0 pd=0 as=0 ps=0
M1131 B0 a_n149_18# Inter_S0 Gnd CMOSN w=5 l=2
+  ad=30 pd=22 as=0 ps=0
M1132 a_22_n384# P3_Not a_22_n345# w_9_n351# CMOSP w=40 l=2
+  ad=200 pd=90 as=320 ps=96
M1133 a_223_n198# C2_Inter_01 vdd w_210_n204# CMOSP w=40 l=2
+  ad=0 pd=0 as=0 ps=0
M1134 P1_Not B1 a_n99_n99# w_n112_n105# CMOSP w=80 l=2
+  ad=400 pd=170 as=0 ps=0
M1135 P3_Not B3 a_n95_n496# w_n108_n502# CMOSP w=80 l=2
+  ad=400 pd=170 as=0 ps=0
M1136 a_160_n475# C3_Inter_NOR gnd Gnd CMOSN w=20 l=2
+  ad=0 pd=0 as=0 ps=0
M1137 G0_Not A0 a_n149_74# Gnd CMOSN w=40 l=2
+  ad=240 pd=92 as=0 ps=0
M1138 a_90_n34# a_48_n36# gnd Gnd CMOSN w=20 l=2
+  ad=0 pd=0 as=0 ps=0
M1139 a_173_n86# Cin a_173_n125# Gnd CMOSN w=20 l=2
+  ad=120 pd=52 as=160 ps=56
M1140 C1 Inter_S2 S2 w_259_n148# CMOSP w=10 l=2
+  ad=0 pd=0 as=0 ps=0
M1141 C1_Inter_NOR P1_Not gnd Gnd CMOSN w=5 l=2
+  ad=0 pd=0 as=0 ps=0
M1142 vdd C1_Inter_NAND a_151_n355# w_138_n361# CMOSP w=20 l=2
+  ad=0 pd=0 as=160 ps=56
M1143 C1_Inter_NOR P0_Not a_75_n109# w_69_n123# CMOSP w=10 l=2
+  ad=50 pd=30 as=0 ps=0
M1144 P2_Not A2 gnd Gnd CMOSN w=40 l=2
+  ad=0 pd=0 as=0 ps=0
M1145 a_n147_n515# B3 gnd Gnd CMOSN w=40 l=2
+  ad=0 pd=0 as=0 ps=0
M1146 a_n149_18# A0 vdd w_n162_12# CMOSP w=22 l=2
+  ad=110 pd=54 as=0 ps=0
M1147 G1_Not A1 a_n151_n118# Gnd CMOSN w=40 l=2
+  ad=240 pd=92 as=0 ps=0
M1148 Inter_S1 B1 A1 w_n164_n180# CMOSP w=10 l=2
+  ad=0 pd=0 as=50 ps=30
M1149 C3_Inter_01 a_151_n355# gnd Gnd CMOSN w=11 l=2
+  ad=55 pd=32 as=0 ps=0
M1150 a_73_n249# P2_Not vdd w_67_n263# CMOSP w=10 l=2
+  ad=0 pd=0 as=0 ps=0
M1151 S2 C1 a_272_n166# Gnd CMOSN w=5 l=2
+  ad=0 pd=0 as=0 ps=0
M1152 Inter_S1 B1 a_n151_n174# Gnd CMOSN w=5 l=2
+  ad=0 pd=0 as=0 ps=0
M1153 C2 a_223_n237# vdd w_210_n204# CMOSP w=22 l=2
+  ad=0 pd=0 as=0 ps=0
M1154 Inter_S1 a_224_35# S1 Gnd CMOSN w=5 l=2
+  ad=0 pd=0 as=0 ps=0
M1155 a_n147_n571# A3 vdd w_n160_n577# CMOSP w=22 l=2
+  ad=110 pd=54 as=0 ps=0
M1156 C3_Inter_NOR P2_Not a_73_n389# w_67_n403# CMOSP w=10 l=2
+  ad=50 pd=30 as=0 ps=0
M1157 S0 Inter_S0 Cin w_224_121# CMOSP w=10 l=2
+  ad=0 pd=0 as=50 ps=30
M1158 a_46_n316# a_22_n384# gnd Gnd CMOSN w=11 l=2
+  ad=55 pd=32 as=0 ps=0
M1159 a_211_n455# a_7_127# vdd w_198_n461# CMOSP w=40 l=2
+  ad=0 pd=0 as=0 ps=0
M1160 a_n147_n571# A3 gnd Gnd CMOSN w=11 l=2
+  ad=0 pd=0 as=0 ps=0
M1161 vdd A1 G1_Not w_n164_n65# CMOSP w=40 l=2
+  ad=0 pd=0 as=0 ps=0
M1162 C0_Inter_01 a_39_96# gnd Gnd CMOSN w=11 l=2
+  ad=55 pd=32 as=0 ps=0
M1163 B2 A2 Inter_S2 w_n161_n369# CMOSP w=10 l=2
+  ad=60 pd=32 as=0 ps=0
M1164 C3 C3_Inter_02 a_266_n416# Gnd CMOSN w=20 l=2
+  ad=120 pd=52 as=0 ps=0
M1165 B2 a_n148_n363# Inter_S2 Gnd CMOSN w=5 l=2
+  ad=30 pd=22 as=0 ps=0
M1166 gnd C2_Inter_NAND a_223_n237# Gnd CMOSN w=20 l=2
+  ad=0 pd=0 as=0 ps=0
M1167 vdd G2_Not C2_Inter_NAND w_9_n211# CMOSP w=20 l=2
+  ad=0 pd=0 as=0 ps=0
M1168 S3 C2 a_283_n282# Gnd CMOSN w=5 l=2
+  ad=0 pd=0 as=0 ps=0
M1169 a_44_16# G0_Not gnd Gnd CMOSN w=20 l=2
+  ad=0 pd=0 as=0 ps=0
M1170 a_248_n65# C1_Inter_01 gnd Gnd CMOSN w=20 l=2
+  ad=0 pd=0 as=0 ps=0
M1171 a_n96_n288# A2 vdd w_n109_n294# CMOSP w=80 l=2
+  ad=0 pd=0 as=0 ps=0
M1172 G3_Not B3 vdd w_n160_n462# CMOSP w=40 l=2
+  ad=0 pd=0 as=0 ps=0
M1173 a_22_n345# G2_Not vdd w_9_n351# CMOSP w=40 l=2
+  ad=0 pd=0 as=0 ps=0
M1174 a_7_127# Cin vdd w_n6_144# CMOSP w=22 l=2
+  ad=110 pd=54 as=0 ps=0
M1175 a_22_n244# P2_Not a_22_n205# w_9_n211# CMOSP w=40 l=2
+  ad=200 pd=90 as=0 ps=0
M1176 a_39_96# a_7_127# a_39_135# w_26_129# CMOSP w=40 l=2
+  ad=200 pd=90 as=0 ps=0
M1177 vdd C0 a_134_n213# w_121_n219# CMOSP w=20 l=2
+  ad=0 pd=0 as=0 ps=0
M1178 a_173_n125# C1_Inter_NOR gnd Gnd CMOSN w=20 l=2
+  ad=0 pd=0 as=0 ps=0
M1179 gnd C3_Inter_03 a_211_n494# Gnd CMOSN w=20 l=2
+  ad=0 pd=0 as=0 ps=0
M1180 a_224_35# C0 vdd w_211_53# CMOSP w=22 l=2
+  ad=110 pd=54 as=0 ps=0
M1181 a_151_n355# C3_Inter_NOR vdd w_138_n361# CMOSP w=20 l=2
+  ad=0 pd=0 as=0 ps=0
C0 w_270_n264# a_283_n282# 0.02fF
C1 a_7_127# Inter_S2 0.06fF
C2 w_160_n92# a_173_n86# 0.22fF
C3 gnd C2_Inter_NAND 0.09fF
C4 w_138_n361# C1_Inter_NAND 0.06fF
C5 a_7_127# vdd 0.05fF
C6 P0_Not G0_Not 0.68fF
C7 A0 gnd 0.26fF
C8 vdd w_n164_n65# 0.09fF
C9 w_138_n361# C3_Inter_01 0.02fF
C10 a_7_127# a_39_96# 0.19fF
C11 Inter_S2 A2 0.06fF
C12 C2_Inter_NAND G2_Not 0.03fF
C13 vdd P2_Not 0.08fF
C14 w_259_n148# a_272_n166# 0.02fF
C15 gnd a_46_n176# 0.95fF
C16 vdd w_n164_n180# 0.02fF
C17 w_210_n204# C2_Inter_01 0.06fF
C18 G2_Not a_46_n176# 0.24fF
C19 C1_Inter_NAND a_151_n355# 0.02fF
C20 vdd w_n162_12# 0.02fF
C21 w_224_121# Cin 0.26fF
C22 C3_Inter_01 a_151_n355# 0.05fF
C23 w_n109_n294# Inter_S2 0.48fF
C24 w_67_n403# C3_Inter_NOR 0.06fF
C25 B1 a_n151_n174# 0.17fF
C26 a_22_n384# G3_Not 0.01fF
C27 w_n161_n254# G2_Not 0.15fF
C28 G0_Not Inter_S0 0.05fF
C29 gnd a_237_103# 0.05fF
C30 w_n109_n294# vdd 0.02fF
C31 C1_Inter_NOR C3_Inter_NOR 0.30fF
C32 gnd Inter_S3 0.78fF
C33 w_n161_n369# Inter_S2 0.02fF
C34 w_253_n383# C3 0.15fF
C35 w_n161_n369# vdd 0.02fF
C36 G3_Not A3 0.27fF
C37 gnd G1_Not 0.14fF
C38 gnd a_n148_n363# 0.07fF
C39 w_9_n351# G2_Not 0.06fF
C40 G1_Not G2_Not 0.06fF
C41 P0_Not P1_Not 0.03fF
C42 w_11_n71# G1_Not 0.09fF
C43 w_9_n211# vdd 0.28fF
C44 C1_Inter_NOR C2_Inter_NAND 0.05fF
C45 Inter_S0 a_n149_18# 0.05fF
C46 A0 w_n110_87# 0.06fF
C47 w_235_n32# C1 0.02fF
C48 vdd C3_Inter_NOR 0.19fF
C49 a_224_35# S1 0.05fF
C50 vdd w_31_49# 0.07fF
C51 P2_Not a_22_n384# 0.02fF
C52 w_n108_n502# vdd 0.21fF
C53 C1_Inter_01 C1_Inter_NAND 0.22fF
C54 C2 a_283_n282# 0.17fF
C55 C3_Inter_04 a_211_n494# 0.04fF
C56 w_121_n219# a_134_n213# 0.22fF
C57 gnd a_173_n86# 0.02fF
C58 w_259_n148# C1 0.55fF
C59 w_160_n92# C1_Inter_NOR 0.06fF
C60 Cin C0_Inter_01 0.58fF
C61 vdd B3 0.00fF
C62 w_198_n461# a_211_n494# 0.09fF
C63 B3 a_n147_n571# 0.17fF
C64 Inter_S1 A1 0.06fF
C65 Cin Inter_S1 0.05fF
C66 w_206_n317# C3_Inter_NAND 0.06fF
C67 vdd C2_Inter_NAND 0.13fF
C68 B0 G0_Not 0.49fF
C69 P0_Not a_7_127# 0.45fF
C70 B1 G1_Not 0.29fF
C71 w_31_49# C0 0.15fF
C72 C1_Inter_NAND C3_Inter_NOR 0.31fF
C73 vdd a_46_n176# 0.12fF
C74 gnd G2_Not 0.14fF
C75 C3_Inter_NAND a_46_n316# 0.09fF
C76 vdd w_160_n92# 0.09fF
C77 G1_Not a_24_n65# 0.01fF
C78 P2_Not B2 0.19fF
C79 w_n6_144# Cin 0.06fF
C80 B2 A2 1.61fF
C81 w_n161_n254# vdd 0.09fF
C82 C0 C2_Inter_NAND 0.05fF
C83 C2_Inter_NAND a_223_n237# 0.19fF
C84 B0 a_n149_18# 0.17fF
C85 a_7_127# Inter_S0 0.04fF
C86 G0_Not C0_Inter_01 0.32fF
C87 C1_Inter_NAND C2_Inter_NAND 0.11fF
C88 a_248_n65# C1 0.04fF
C89 G3_Not a_46_n316# 0.24fF
C90 G0_Not Inter_S1 0.05fF
C91 gnd a_224_35# 0.07fF
C92 w_235_n32# C1_Inter_01 0.06fF
C93 Inter_S3 a_n147_n571# 0.05fF
C94 w_121_n219# C2_Inter_01 0.02fF
C95 G1_Not Inter_S2 0.06fF
C96 w_n109_n294# B2 0.06fF
C97 Inter_S2 a_n148_n363# 0.05fF
C98 w_9_n351# vdd 0.28fF
C99 C1_Inter_NAND a_46_n176# 0.00fF
C100 C3_Inter_02 C3_Inter_04 0.23fF
C101 vdd G1_Not 0.22fF
C102 gnd B1 0.06fF
C103 w_n112_n105# G1_Not 0.01fF
C104 w_n162_12# Inter_S0 0.06fF
C105 w_n108_n502# A3 0.06fF
C106 w_210_n204# C2 0.02fF
C107 w_n161_n369# B2 0.40fF
C108 w_n160_n462# vdd 0.09fF
C109 G0_Not a_24_n104# 0.02fF
C110 Inter_S0 S0 0.35fF
C111 B0 w_n162_127# 0.06fF
C112 B3 A3 1.61fF
C113 w_121_n219# C2_Inter_NOR 0.06fF
C114 gnd C1_Inter_NOR 0.54fF
C115 vdd w_26_129# 0.11fF
C116 w_26_129# a_39_96# 0.09fF
C117 P2_Not a_46_n316# 0.07fF
C118 w_69_n123# P1_Not 0.06fF
C119 a_283_n282# S3 0.05fF
C120 gnd C3_Inter_04 0.46fF
C121 w_270_n264# C2 0.40fF
C122 P1_Not C2_Inter_NOR 0.26fF
C123 C1_Inter_NAND G1_Not 0.03fF
C124 gnd Inter_S2 0.18fF
C125 A0 P0_Not 0.03fF
C126 gnd a_n147_n571# 0.07fF
C127 vdd gnd 2.24fF
C128 Inter_S2 G2_Not 0.10fF
C129 C1_Inter_01 a_248_n65# 0.03fF
C130 w_224_121# S0 0.02fF
C131 w_211_53# S1 0.02fF
C132 C3_Inter_01 C3_Inter_02 0.03fF
C133 vdd G2_Not 0.15fF
C134 vdd w_11_n71# 0.23fF
C135 w_9_n351# a_22_n384# 0.09fF
C136 G1_Not a_n99_n99# 0.01fF
C137 A1 P1_Not 0.03fF
C138 a_22_n205# G2_Not 0.01fF
C139 B0 w_n162_12# 0.40fF
C140 G1_Not a_48_n36# 0.24fF
C141 P3_Not G3_Not 0.00fF
C142 P1_Not a_24_n104# 0.20fF
C143 P2_Not C2_Inter_NOR 0.02fF
C144 w_n161_n254# B2 0.06fF
C145 a_7_127# Inter_S1 0.04fF
C146 gnd C0 1.19fF
C147 vdd a_73_n249# 0.01fF
C148 gnd C1_Inter_NAND 0.19fF
C149 gnd C3_Inter_01 0.19fF
C150 C1_Inter_NAND G2_Not 0.00fF
C151 w_67_n263# vdd 0.19fF
C152 w_n160_n462# A3 0.06fF
C153 P0_Not G1_Not 0.05fF
C154 w_n164_n180# Inter_S1 0.02fF
C155 w_11_n71# C1_Inter_NAND 0.15fF
C156 w_n112_n105# B1 0.06fF
C157 w_n164_n65# A1 0.06fF
C158 a_7_127# Cin 0.08fF
C159 a_7_127# P3_Not 0.04fF
C160 P2_Not P3_Not 0.03fF
C161 w_67_n403# vdd 0.19fF
C162 C1_Inter_NOR Inter_S2 0.03fF
C163 C1 a_272_n166# 0.17fF
C164 a_237_103# Inter_S0 0.17fF
C165 G0_Not P1_Not 0.10fF
C166 B2 a_n148_n363# 0.17fF
C167 w_n164_n180# A1 0.26fF
C168 w_198_n461# C3_Inter_04 0.02fF
C169 C0 a_224_35# 0.16fF
C170 vdd C1_Inter_NOR 0.24fF
C171 gnd a_48_n36# 0.95fF
C172 P0_Not w_26_129# 0.06fF
C173 G0_Not w_n162_127# 0.15fF
C174 a_7_127# w_n6_144# 0.02fF
C175 vdd w_n110_87# 0.02fF
C176 P1_Not a_22_n244# 0.02fF
C177 G2_Not a_22_n384# 0.02fF
C178 Inter_S3 a_283_n282# 0.16fF
C179 w_11_n71# a_48_n36# 0.10fF
C180 w_198_n461# vdd 0.11fF
C181 gnd A3 0.26fF
C182 w_270_n264# S3 0.02fF
C183 C2_Inter_01 C2_Inter_NAND 0.36fF
C184 vdd Inter_S2 0.16fF
C185 B0 A0 1.61fF
C186 P0_Not gnd 0.17fF
C187 a_7_127# G0_Not 0.03fF
C188 vdd w_n112_n105# 0.02fF
C189 gnd w_235_n32# 0.03fF
C190 C0 C1_Inter_NOR 0.07fF
C191 w_224_121# a_237_103# 0.02fF
C192 w_31_49# C0_Inter_01 0.06fF
C193 w_211_53# a_224_35# 0.02fF
C194 C1_Inter_NAND C1_Inter_NOR 0.15fF
C195 C3_Inter_NAND G3_Not 0.03fF
C196 w_259_n148# S2 0.02fF
C197 P0_Not w_11_n71# 0.17fF
C198 gnd B2 0.06fF
C199 P2_Not a_22_n244# 0.20fF
C200 w_206_n317# C3_Inter_02 0.02fF
C201 w_9_n351# a_46_n316# 0.10fF
C202 Inter_S1 a_n151_n174# 0.05fF
C203 w_210_n204# C2_Inter_NAND 0.06fF
C204 G2_Not B2 0.26fF
C205 P3_Not C3_Inter_NOR 0.02fF
C206 C0 Inter_S2 0.04fF
C207 w_n108_n502# P3_Not 0.02fF
C208 A1 a_n151_n174# 0.16fF
C209 C1_Inter_NAND Inter_S2 0.11fF
C210 vdd C0 0.08fF
C211 gnd Inter_S0 0.34fF
C212 gnd a_134_n213# 0.02fF
C213 P3_Not B3 0.19fF
C214 vdd C1_Inter_NAND 0.08fF
C215 w_138_n361# a_151_n355# 0.22fF
C216 C3_Inter_02 C3 0.02fF
C217 w_n162_12# a_n149_18# 0.02fF
C218 a_7_127# P1_Not 0.05fF
C219 P0_Not a_24_n65# 0.01fF
C220 w_160_n92# Cin 0.06fF
C221 a_7_127# G3_Not 0.03fF
C222 vdd a_48_n36# 0.12fF
C223 P0_Not C1_Inter_NOR 0.26fF
C224 P0_Not w_n110_87# 0.02fF
C225 gnd a_46_n316# 0.95fF
C226 P1_Not P2_Not 0.03fF
C227 w_147_n442# C3_Inter_03 0.15fF
C228 w_n160_n577# B3 0.40fF
C229 Inter_S1 S1 0.35fF
C230 C0 C1_Inter_NAND 0.05fF
C231 w_9_n211# a_22_n244# 0.09fF
C232 vdd w_211_53# 0.03fF
C233 G0_Not w_31_49# 0.06fF
C234 P2_Not G3_Not 0.15fF
C235 C2 S3 0.35fF
C236 Cin a_237_103# 0.16fF
C237 gnd C3 0.05fF
C238 a_7_127# C3_Inter_03 0.28fF
C239 vdd A3 0.00fF
C240 A3 a_n147_n571# 0.16fF
C241 w_270_n264# Inter_S3 0.26fF
C242 Inter_S1 G1_Not 0.05fF
C243 gnd C2_Inter_01 0.02fF
C244 P0_Not vdd 0.16fF
C245 B0 gnd 0.06fF
C246 A0 G0_Not 0.50fF
C247 vdd w_235_n32# 0.12fF
C248 A1 G1_Not 0.27fF
C249 w_26_129# C0_Inter_01 0.05fF
C250 w_9_n351# P3_Not 0.06fF
C251 P0_Not a_39_96# 0.03fF
C252 Inter_S2 B2 0.86fF
C253 C1_Inter_NAND a_48_n36# 0.09fF
C254 w_211_53# C0 0.26fF
C255 a_7_127# P2_Not 0.08fF
C256 w_259_n148# Inter_S2 0.26fF
C257 vdd w_259_n148# 0.03fF
C258 G1_Not a_24_n104# 0.01fF
C259 P2_Not A2 0.03fF
C260 a_22_n244# a_46_n176# 0.05fF
C261 gnd C2_Inter_NOR 0.40fF
C262 w_n160_n577# Inter_S3 0.06fF
C263 w_9_n211# P1_Not 0.17fF
C264 w_253_n383# C3_Inter_02 0.06fF
C265 w_138_n361# C3_Inter_NOR 0.06fF
C266 Cin a_173_n86# 0.02fF
C267 a_22_n345# G3_Not 0.01fF
C268 vdd Inter_S0 0.10fF
C269 gnd C0_Inter_01 0.06fF
C270 A0 a_n149_18# 0.16fF
C271 gnd Inter_S1 0.23fF
C272 w_235_n32# C1_Inter_NAND 0.06fF
C273 w_n109_n294# P2_Not 0.02fF
C274 w_n109_n294# A2 0.06fF
C275 w_206_n317# vdd 0.08fF
C276 G3_Not B3 0.26fF
C277 gnd A1 0.26fF
C278 G0_Not G1_Not 0.06fF
C279 gnd Cin 0.06fF
C280 w_147_n442# C3_Inter_NOR 0.06fF
C281 gnd P3_Not 0.48fF
C282 G1_Not a_22_n244# 0.02fF
C283 w_n161_n369# A2 0.26fF
C284 G2_Not P3_Not 0.20fF
C285 w_253_n383# gnd 0.04fF
C286 P0_Not a_48_n36# 0.07fF
C287 Inter_S0 C0 0.11fF
C288 B0 w_n110_87# 0.06fF
C289 A0 w_n162_127# 0.06fF
C290 C0 a_134_n213# 0.02fF
C291 vdd a_46_n316# 0.12fF
C292 a_224_35# Inter_S1 0.17fF
C293 w_67_n263# C2_Inter_NOR 0.06fF
C294 vdd w_224_121# 0.02fF
C295 w_9_n211# P2_Not 0.06fF
C296 P2_Not a_22_n345# 0.01fF
C297 P1_Not a_46_n176# 0.07fF
C298 P2_Not C3_Inter_NOR 0.26fF
C299 C2 Inter_S3 0.13fF
C300 w_11_n71# a_24_n104# 0.09fF
C301 vdd a_75_n109# 0.01fF
C302 w_69_n123# C1_Inter_NOR 0.06fF
C303 C3_Inter_03 a_211_n494# 0.19fF
C304 Inter_S1 B1 0.86fF
C305 a_272_n166# S2 0.05fF
C306 w_9_n351# C3_Inter_NAND 0.15fF
C307 w_206_n317# C3_Inter_01 0.06fF
C308 C1_Inter_NOR C2_Inter_NOR 0.01fF
C309 w_n164_n180# a_n151_n174# 0.02fF
C310 a_7_127# a_211_n494# 0.03fF
C311 B1 A1 1.61fF
C312 G0_Not gnd 0.02fF
C313 C1_Inter_NAND a_248_n65# 0.19fF
C314 C3_Inter_NAND C3_Inter_02 0.19fF
C315 vdd w_69_n123# 0.19fF
C316 G0_Not w_11_n71# 0.06fF
C317 w_67_n403# P3_Not 0.06fF
C318 w_9_n351# G3_Not 0.09fF
C319 G1_Not P1_Not 0.06fF
C320 a_22_n244# G2_Not 0.01fF
C321 A0 w_n162_12# 0.26fF
C322 Cin C1_Inter_NOR 0.31fF
C323 w_210_n204# vdd 0.12fF
C324 vdd C2_Inter_NOR 0.13fF
C325 w_n160_n462# G3_Not 0.15fF
C326 vdd C0_Inter_01 0.07fF
C327 P0_Not Inter_S0 0.05fF
C328 C2_Inter_01 a_223_n237# 0.03fF
C329 a_22_n384# a_46_n316# 0.05fF
C330 a_39_96# C0_Inter_01 0.04fF
C331 w_n161_n254# A2 0.06fF
C332 vdd Inter_S1 0.17fF
C333 gnd a_n149_18# 0.07fF
C334 w_n112_n105# Inter_S1 0.48fF
C335 gnd C2 0.06fF
C336 gnd C3_Inter_NAND 0.09fF
C337 w_253_n383# C3_Inter_04 0.06fF
C338 w_270_n264# vdd 0.02fF
C339 a_7_127# G1_Not 0.16fF
C340 w_n164_n65# G1_Not 0.15fF
C341 w_160_n92# C1_Inter_01 0.02fF
C342 w_n112_n105# A1 0.06fF
C343 vdd Cin 0.10fF
C344 vdd P3_Not 0.06fF
C345 w_9_n351# P2_Not 0.17fF
C346 G1_Not P2_Not 0.32fF
C347 w_n108_n502# B3 0.06fF
C348 C0 C2_Inter_NOR 0.26fF
C349 w_210_n204# a_223_n237# 0.09fF
C350 w_9_n211# C2_Inter_NAND 0.15fF
C351 w_253_n383# vdd 0.06fF
C352 C1_Inter_NAND C2_Inter_NOR 0.01fF
C353 C1 S2 0.35fF
C354 a_237_103# S0 0.05fF
C355 C0_Inter_01 C0 0.02fF
C356 gnd P1_Not 0.47fF
C357 w_235_n32# a_248_n65# 0.09fF
C358 A2 a_n148_n363# 0.16fF
C359 gnd G3_Not 0.12fF
C360 vdd w_n6_144# 0.02fF
C361 a_7_127# w_26_129# 0.07fF
C362 C0 Inter_S1 0.23fF
C363 gnd C1 0.46fF
C364 P1_Not G2_Not 0.09fF
C365 G2_Not G3_Not 0.05fF
C366 w_9_n211# a_46_n176# 0.10fF
C367 w_11_n71# P1_Not 0.06fF
C368 vdd a_73_n389# 0.01fF
C369 gnd a_151_n355# 0.02fF
C370 Cin C0 0.32fF
C371 gnd C3_Inter_03 0.02fF
C372 w_n160_n577# a_n147_n571# 0.02fF
C373 Inter_S2 a_272_n166# 0.16fF
C374 w_n160_n577# vdd 0.02fF
C375 Cin C1_Inter_NAND 0.05fF
C376 B0 P0_Not 0.19fF
C377 vdd G0_Not 0.10fF
C378 a_7_127# gnd 0.15fF
C379 w_n161_n369# a_n148_n363# 0.02fF
C380 w_224_121# Inter_S0 0.40fF
C381 C2_Inter_NAND a_46_n176# 0.09fF
C382 w_211_53# Inter_S1 0.40fF
C383 a_7_127# G2_Not 0.13fF
C384 gnd P2_Not 0.58fF
C385 w_67_n263# P1_Not 0.06fF
C386 C1_Inter_NOR C3_Inter_NAND 0.04fF
C387 P0_Not w_69_n123# 0.06fF
C388 gnd A2 0.26fF
C389 B1 P1_Not 0.19fF
C390 w_121_n219# C1_Inter_NOR 0.03fF
C391 w_9_n211# G1_Not 0.06fF
C392 P2_Not G2_Not 0.15fF
C393 C1_Inter_01 a_173_n86# 0.05fF
C394 P3_Not a_22_n384# 0.20fF
C395 G2_Not A2 0.27fF
C396 Inter_S3 B3 0.42fF
C397 B0 Inter_S0 0.42fF
C398 C2_Inter_01 a_134_n213# 0.05fF
C399 P1_Not C1_Inter_NOR 0.02fF
C400 a_24_n104# a_48_n36# 0.05fF
C401 P0_Not Inter_S1 0.05fF
C402 vdd C2 0.29fF
C403 P3_Not A3 0.03fF
C404 gnd C1_Inter_01 0.42fF
C405 vdd C3_Inter_NAND 0.13fF
C406 w_121_n219# vdd 0.09fF
C407 w_n160_n462# B3 0.06fF
C408 P0_Not Cin 0.05fF
C409 w_n164_n65# B1 0.06fF
C410 w_67_n263# P2_Not 0.06fF
C411 w_147_n442# C1_Inter_NOR 0.06fF
C412 C1_Inter_NOR C3_Inter_03 0.02fF
C413 P1_Not Inter_S2 0.06fF
C414 w_138_n361# vdd 0.09fF
C415 C1 Inter_S2 0.12fF
C416 P0_Not a_24_n104# 0.02fF
C417 vdd P1_Not 0.13fF
C418 w_n112_n105# P1_Not 0.02fF
C419 w_n164_n180# B1 0.40fF
C420 vdd G3_Not 0.19fF
C421 Inter_S0 Inter_S1 0.40fF
C422 w_67_n403# P2_Not 0.06fF
C423 vdd C1 0.06fF
C424 vdd w_n162_127# 0.09fF
C425 gnd C3_Inter_NOR 0.43fF
C426 P1_Not a_22_n205# 0.01fF
C427 w_n160_n577# A3 0.26fF
C428 w_198_n461# C3_Inter_03 0.06fF
C429 w_9_n211# G2_Not 0.09fF
C430 a_223_n237# C2 0.04fF
C431 w_121_n219# C0 0.06fF
C432 C1_Inter_NAND C3_Inter_NAND 0.04fF
C433 gnd a_n151_n174# 0.07fF
C434 Cin Inter_S0 0.23fF
C435 C3_Inter_01 C3_Inter_NAND 0.25fF
C436 w_147_n442# vdd 0.11fF
C437 w_198_n461# a_7_127# 0.06fF
C438 gnd B3 0.06fF
C439 a_n147_n571# Gnd 0.61fF
C440 a_211_n494# Gnd 0.17fF
C441 C3_Inter_03 Gnd 0.09fF
C442 A3 Gnd 0.99fF
C443 B3 Gnd 0.42fF
C444 C3 Gnd 0.19fF
C445 C3_Inter_04 Gnd 0.44fF
C446 a_151_n355# Gnd 0.29fF
C447 C3_Inter_NOR Gnd 0.95fF
C448 a_46_n316# Gnd 0.34fF
C449 C3_Inter_02 Gnd 0.48fF
C450 G3_Not Gnd 0.12fF
C451 a_22_n384# Gnd 0.17fF
C452 a_n148_n363# Gnd 0.61fF
C453 P3_Not Gnd 0.03fF
C454 C3_Inter_NAND Gnd 2.00fF
C455 C3_Inter_01 Gnd 0.38fF
C456 S3 Gnd 0.06fF
C457 a_283_n282# Gnd 0.61fF
C458 Inter_S3 Gnd 8.01fF
C459 C2 Gnd 1.00fF
C460 a_223_n237# Gnd 0.17fF
C461 a_134_n213# Gnd 0.29fF
C462 C2_Inter_NOR Gnd 0.38fF
C463 A2 Gnd 0.99fF
C464 B2 Gnd 0.42fF
C465 a_46_n176# Gnd 0.34fF
C466 G2_Not Gnd 0.12fF
C467 a_22_n244# Gnd 0.17fF
C468 P2_Not Gnd 2.82fF
C469 C2_Inter_NAND Gnd 2.25fF
C470 C2_Inter_01 Gnd 0.36fF
C471 S2 Gnd 0.06fF
C472 a_272_n166# Gnd 0.61fF
C473 Inter_S2 Gnd 2.08fF
C474 a_n151_n174# Gnd 0.61fF
C475 a_173_n86# Gnd 0.43fF
C476 C1_Inter_NOR Gnd 2.56fF
C477 C1 Gnd 1.46fF
C478 a_48_n36# Gnd 0.34fF
C479 a_248_n65# Gnd 0.17fF
C480 a_24_n104# Gnd 0.17fF
C481 P1_Not Gnd 2.74fF
C482 G1_Not Gnd 0.12fF
C483 A1 Gnd 0.99fF
C484 B1 Gnd 0.42fF
C485 C1_Inter_NAND Gnd 2.95fF
C486 C1_Inter_01 Gnd 0.44fF
C487 S1 Gnd 0.06fF
C488 Inter_S1 Gnd 4.39fF
C489 a_224_35# Gnd 0.61fF
C490 a_n149_18# Gnd 0.61fF
C491 C0 Gnd 0.09fF
C492 S0 Gnd 0.04fF
C493 Inter_S0 Gnd 4.34fF
C494 a_237_103# Gnd 0.61fF
C495 C0_Inter_01 Gnd 0.11fF
C496 a_39_96# Gnd 0.04fF
C497 Cin Gnd 1.21fF
C498 gnd Gnd 15.65fF
C499 G0_Not Gnd 3.97fF
C500 vdd Gnd 12.71fF
C501 a_7_127# Gnd 4.69fF
C502 P0_Not Gnd 4.11fF
C503 A0 Gnd 0.92fF
C504 B0 Gnd 1.13fF
C505 w_n160_n577# Gnd 1.44fF
C506 w_198_n461# Gnd 2.34fF
C507 w_147_n442# Gnd 1.09fF
C508 w_n108_n502# Gnd 3.14fF
C509 w_n160_n462# Gnd 1.31fF
C510 w_253_n383# Gnd 1.09fF
C511 w_67_n403# Gnd 0.82fF
C512 w_138_n361# Gnd 1.69fF
C513 w_n161_n369# Gnd 1.44fF
C514 w_206_n317# Gnd 1.78fF
C515 w_9_n351# Gnd 0.37fF
C516 w_270_n264# Gnd 1.31fF
C517 w_67_n263# Gnd 0.82fF
C518 w_121_n219# Gnd 1.69fF
C519 w_n109_n294# Gnd 3.14fF
C520 w_n161_n254# Gnd 1.31fF
C521 w_210_n204# Gnd 2.34fF
C522 w_9_n211# Gnd 0.08fF
C523 w_n164_n180# Gnd 1.44fF
C524 w_259_n148# Gnd 1.44fF
C525 w_160_n92# Gnd 1.69fF
C526 w_69_n123# Gnd 0.82fF
C527 w_11_n71# Gnd 0.37fF
C528 w_n112_n105# Gnd 3.14fF
C529 w_n164_n65# Gnd 1.31fF
C530 w_235_n32# Gnd 2.34fF
C531 w_n162_12# Gnd 1.44fF
C532 w_211_53# Gnd 1.44fF
C533 w_31_49# Gnd 1.09fF
C534 w_224_121# Gnd 1.44fF
C535 w_26_129# Gnd 2.34fF
C536 w_n6_144# Gnd 0.82fF
C537 w_n110_87# Gnd 0.90fF
C538 w_n162_127# Gnd 0.37fF

VA3 A3 gnd 0
VA2 A2 gnd 'SUPPLY'
VA1 A1 gnd 'SUPPLY'
VA0 A0 gnd 'SUPPLY'

VB3 B3 gnd 'SUPPLY'
VB2 B2 gnd 0
VB1 B1 gnd 'SUPPLY'
VB0 B0 gnd pulse 0 'SUPPLY' 0 10p 10p 1n 2n

VCin Cin gnd 'SUPPLY'

.tran 10p 10n

.control

run
set hcopypscolor = 1
set color0 = white
set color1 = black
set curplottitle = "Siddarth Gottumukkula 2023102040"
set xbrushwidth = 3

* 10010 Output

let in_A3 = 'A3 + 26'
let in_A2 = 'A2 + 24'
let in_A1 = 'A1 + 22'
let in_A0 = 'A0 + 20'

let in_B3 = 'B3 + 18'
let in_B2 = 'B2 + 16'
let in_B1 = 'B1 + 14'
let in_B0 = 'B0 + 12'

let in_Cin = 'Cin + 10'

let out_Cout = 'C3 + 8'
let out_S3 = 'S3 + 6'
let out_S2 = 'S2 + 4'
let out_S1 = 'S1 + 2'
let out_S0 = 'S0'

* plot in_A3 in_A2 in_A1 in_A0 in_B3 in_B2 in_B1 in_B0 in_Cin out_Cout out_S3 out_S2 out_S1 out_S0
* plot in_A3 in_A2 in_A1 in_A0 in_B3 in_B2 in_B1 in_B0
plot out_Cout out_S3 out_S2 out_S1 out_S0
* plot Inter_S0 Inter_S1+2 Inter_S2+4 Inter_S3+6
* plot P0_Not   P1_Not+2 P2_Not+4 P3_Not+6
* plot G0_Not G1_Not+2 G2_Not+4 G3_Not+6
* plot C1_inter_NAND + 4 C1_inter_01 + 2 Intermediate

.endc

.end
