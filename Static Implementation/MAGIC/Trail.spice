* SPICE3 file created from Trail.ext - technology: scmos

.include "TSMC_180nm.txt"
.param SUPPLY = 1.8

Vdd vdd gnd 'SUPPLY'
VClk V_In gnd pulse SUPPLY 0 0 1p 1p 0.25ns 0.5ns

.option scale=0.09u

M1000 V_Out V_In VDD w_n6_10# CMOSP w=4 l=2
+  ad=20 pd=18 as=20 ps=18
M1001 V_Out V_In GND Gnd CMOSN w=4 l=2
+  ad=20 pd=18 as=20 ps=18
C0 V_Out GND 0.10fF
C1 GND V_In 0.05fF
C2 V_Out V_In 0.05fF
C3 V_Out w_n6_10# 0.03fF
C4 V_Out VDD 0.10fF
C5 V_In w_n6_10# 0.06fF
C6 VDD V_In 0.04fF
C7 VDD w_n6_10# 0.06fF
C8 GND Gnd 0.09fF
C9 V_Out Gnd 0.03fF
C10 VDD Gnd 0.03fF
C11 V_In Gnd 0.11fF
C12 w_n6_10# Gnd 0.39fF

.tran 1p 5ns

.measure tran trise
+ TRIG V(V_Out) VAL = 'SUPPLY / 10' RISE = 1
+ TARG V(V_Out) VAL = '9 * SUPPLY / 10' RISE = 1

.measure tran tfall
+ TRIG V(V_Out) VAL = '9 * SUPPLY / 10' FALL = 1
+ TARG V(V_Out) VAL = 'SUPPLY / 10' FALL = 1

.measure tran delay param = '(trise + tfall) / 2'

.measure tran tcqrise
+ TRIG V(V_In) VAL = 'SUPPLY / 2' RISE = 1
+ TARG V(V_Out) VAL = 'SUPPLY / 2' FALL = 1

.measure tran tcqfall
+ TRIG V(V_In) VAL = 'SUPPLY / 2' FALL = 2
+ TARG V(V_Out) VAL = 'SUPPLY / 2' RISE = 2

.measure tran tcq param = '(tcqrise + tcqfall) / 2'

.control

run
set hcopypscolor = 1
set color0 = white
set color1 = black
set curplottitle = "Siddarth Gottumukkula 2023102040"
set xbrushwidth = 3

plot (V_In+2) V_Out

.endc

.end
