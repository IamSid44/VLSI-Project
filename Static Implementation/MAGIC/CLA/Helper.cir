* Extracted Netlist
.include TSMC_180nm.txt
.param SUPPLY=1.8
.global gnd vdd

* Supply
Vdd vdd gnd 'SUPPLY'

* SPICE3 file created from Helper.ext - technology: scmos

.option scale=0.09u

M1000 OR_out a_n50_6# gnd Gnd CMOSN w=11 l=2
+  ad=55 pd=32 as=405 ps=222
M1001 a_n50_45# Gi_1_not vdd w_n63_39# CMOSP w=40 l=2
+  ad=320 pd=96 as=570 ps=276
M1002 vdd Gi_not inter_NAND w_n63_39# CMOSP w=20 l=2
+  ad=0 pd=0 as=160 ps=56
M1003 inter_NOR Pi_not gnd Gnd CMOSN w=5 l=2
+  ad=40 pd=26 as=0 ps=0
M1004 a_16_76# OR_out gnd Gnd CMOSN w=20 l=2
+  ad=160 pd=56 as=0 ps=0
M1005 OR_out a_n50_6# vdd w_n63_39# CMOSP w=22 l=2
+  ad=110 pd=54 as=0 ps=0
M1006 a_n50_6# Pi_not a_n50_45# w_n63_39# CMOSP w=40 l=2
+  ad=200 pd=90 as=0 ps=0
M1007 gnd Pi_1_not inter_NOR Gnd CMOSN w=5 l=2
+  ad=0 pd=0 as=0 ps=0
M1008 inter_NAND OR_out vdd w_n63_39# CMOSP w=20 l=2
+  ad=0 pd=0 as=0 ps=0
M1009 a_1_1# Pi_not vdd w_n5_n13# CMOSP w=10 l=2
+  ad=80 pd=36 as=0 ps=0
M1010 gnd Pi_not a_n50_6# Gnd CMOSN w=20 l=2
+  ad=0 pd=0 as=160 ps=56
M1011 inter_NOR Pi_1_not a_1_1# w_n5_n13# CMOSP w=10 l=2
+  ad=50 pd=30 as=0 ps=0
M1012 inter_NAND Gi_not a_16_76# Gnd CMOSN w=20 l=2
+  ad=120 pd=52 as=0 ps=0
M1013 a_n50_6# Gi_1_not gnd Gnd CMOSN w=20 l=2
+  ad=0 pd=0 as=0 ps=0
C0 Gi_1_not a_n50_6# 0.02fF
C1 gnd Pi_1_not 0.09fF
C2 OR_out Pi_1_not 0.07fF
C3 w_n63_39# OR_out 0.10fF
C4 a_n50_45# Pi_1_not 0.01fF
C5 inter_NAND gnd 0.06fF
C6 Pi_not Pi_1_not 0.03fF
C7 vdd inter_NOR 0.13fF
C8 inter_NAND OR_out 0.09fF
C9 a_n50_6# Gi_not 0.01fF
C10 w_n63_39# Pi_not 0.06fF
C11 w_n5_n13# inter_NOR 0.06fF
C12 Gi_1_not gnd 0.02fF
C13 vdd Gi_not 0.13fF
C14 Gi_1_not Pi_not 0.03fF
C15 w_n5_n13# vdd 0.19fF
C16 w_n63_39# Pi_1_not 0.17fF
C17 gnd inter_NOR 0.37fF
C18 Gi_not OR_out 0.24fF
C19 vdd a_1_1# 0.01fF
C20 a_n50_6# OR_out 0.05fF
C21 w_n63_39# inter_NAND 0.15fF
C22 vdd gnd 0.06fF
C23 Gi_1_not Pi_1_not 0.00fF
C24 Pi_not inter_NOR 0.02fF
C25 vdd OR_out 0.12fF
C26 a_n50_45# Gi_not 0.01fF
C27 w_n63_39# Gi_1_not 0.06fF
C28 Pi_not Gi_not 0.00fF
C29 Pi_not a_n50_6# 0.20fF
C30 Pi_not vdd 0.00fF
C31 w_n5_n13# Pi_not 0.06fF
C32 inter_NOR Pi_1_not 0.26fF
C33 OR_out gnd 0.95fF
C34 w_n63_39# Gi_not 0.09fF
C35 a_n50_6# Pi_1_not 0.02fF
C36 w_n63_39# a_n50_6# 0.09fF
C37 vdd Pi_1_not 0.03fF
C38 w_n63_39# vdd 0.22fF
C39 Pi_not gnd 0.10fF
C40 w_n5_n13# Pi_1_not 0.06fF
C41 inter_NAND Gi_not 0.03fF
C42 Gi_1_not Gi_not 0.00fF
C43 Pi_1_not Gnd 0.65fF
C44 inter_NOR Gnd 0.15fF
C45 gnd Gnd 0.44fF
C46 OR_out Gnd 0.34fF
C47 Gi_not Gnd 0.30fF
C48 a_n50_6# Gnd 0.17fF
C49 inter_NAND Gnd 0.63fF
C50 Pi_not Gnd 0.75fF
C51 Gi_1_not Gnd 0.16fF
C52 w_n5_n13# Gnd 0.82fF
C53 w_n63_39# Gnd 1.72fF

VDGi_not Gi_Not gnd pulse 0 SUPPLY 0 50p 50p 1.25ns 2.5ns
VDPi_not Pi_Not gnd pulse 0 SUPPLY 0 50p 50p 1ns 2ns
VDGi_1_not Gi_1_Not gnd pulse 0 SUPPLY 0 50p 50p 2.5ns 5ns
VDPi_1_not Pi_1_Not gnd pulse 0 SUPPLY 0 50p 50p 2ns 4ns

.tran 1ps 10ns

.control

run
set hcopypscolor = 1
set color0 = white
set color1 = black
set curplottitle = "Siddarth Gottumukkula 2023102040"
set xbrushwidth = 3

let in1 = 'Gi_not + 10'
let in2 = 'Pi_not + 8'
let in3 = 'Gi_1_not + 6'
let in4 = 'Pi_1_not + 4'
let out1 = 'inter_NAND + 2'
let out2 = 'inter_NOR'

plot in1 in2 in3 in4 out1 out2

.endc

.end
