NGSPICE Netlist for the Carry and Sum Logic of a 4-bit Carry Lookahead Adder

.include "TSMC_180nm.txt"
.param SUPPLY = 1.8
.param LAMBDA = 0.09u
.param width_N = {10 * LAMBDA} ; Vary the width (1)
.param width_P = {2 * width_N} ; Assuming ratio of mobilites is 2, change it (2)
.global gnd vdd

.include "Subcircuits.cir"

Vdd vdd gnd 'SUPPLY'

* 0101 + 1010 + 1 = 10000
* 5 + 10 + 1 = 16

VA3 A3 gnd 0
VA2 A2 gnd 0
VA1 A1 gnd 0
VA0 A0 gnd 0

VB3 B3 gnd 0
VB2 B2 gnd 'SUPPLY'
VB1 B1 gnd 'SUPPLY'
* VB0 B0 gnd pulse 'SUPPLY' 0 0 50p 50p 0.95ns 1.9ns
VB0 B0 gnd pulse 0 'SUPPLY' 0 50p 50p 0.25ns 0.5ns ; Works at 2 GHz also!

VCin Cin gnd 'SUPPLY'

    XPG_Block A3 A2 A1 A0 B3 B2 B1 B0 G3_not G2_not G1_not G0_not P3_not P2_not P1_not P0_not Inter_S0 Inter_S1 Inter_S2 Inter_S3 vdd gnd PG_Ckt

    XInv100 Cin Cin_not vdd gnd Inverter
    XInv101 C0 C0_not vdd gnd Inverter
    XInv102 C1 C1_not vdd gnd Inverter
    XInv103 C2 C2_not vdd gnd Inverter
    XInv104 C3 C3_not vdd gnd Inverter

    XOR01 P0_not Cin_not C0_inter_01 vdd gnd OR_Gate
    XNAND02 G0_not C0_inter_01 C0 vdd gnd NAND_Gate
    XXOR03 Cin Cin_not Inter_S0 S0 vdd gnd XOR_Gate

    XHelper10 G1_not P1_not G0_not P0_not C1_inter_nand C1_inter_nor vdd gnd Helper
    XAND11 Cin C1_inter_nor C1_inter_01 vdd gnd AND_Gate
    XOR12 C1_inter_nand C1_inter_01 C1 vdd gnd OR_Gate
    XXOR13 C0 C0_not Inter_S1 S1 vdd gnd XOR_Gate

    XHelper20 G2_not P2_not G1_not P1_not C2_inter_nand C2_inter_nor vdd gnd Helper
    XAND21 C0 C2_inter_nor C2_inter_01 vdd gnd AND_Gate
    XOR22 C2_inter_nand C2_inter_01 C2 vdd gnd OR_Gate
    XXOR23 C1 C1_not Inter_S2 S2 vdd gnd XOR_Gate

    XHelper30 G3_not P3_not G2_not P2_not C3_inter_nand C3_inter_nor vdd gnd Helper
    XAND31 C1_inter_nand C3_inter_nor C3_inter_01 vdd gnd AND_Gate
    XNOR32 C3_inter_nand C3_inter_01 C3_inter_02 vdd gnd Small_NOR_Gate
    XNAND33 C3_inter_nor C1_inter_nor C3_inter_03 vdd gnd NAND_Gate
    XOR34 C3_inter_03 Cin_not C3_inter_04 vdd gnd OR_Gate
    XNAND35 C3_inter_02 C3_inter_04 C3 vdd gnd NAND_Gate
    XXOR36 C2 C2_not Inter_S3 S3 vdd gnd XOR_Gate

* .measure tran C_out_measured FIND V(C3) AT = 5n
* .measure tran S3_measured FIND V(S3) AT = 5n
* .measure tran S2_measured FIND V(S2) AT = 5n
* .measure tran S1_measured FIND V(S1) AT = 5n
* .measure tran S0_measured FIND V(S0) AT = 5n

.tran 1p 3n

.ic V(S0) = 0
.ic V(S1) = 0
.ic V(S2) = 0
.ic V(S3) = 0
.ic V(C3) = 0

.control

run
set hcopypscolor = 1
set color0 = white
set color1 = black
set curplottitle = "Siddarth Gottumukkula 2023102040"
set xbrushwidth = 3
set ybrushwidth = 3

let in_A3 = 'A3 + 26'
let in_A2 = 'A2 + 24'
let in_A1 = 'A1 + 22'
let in_A0 = 'A0 + 20'

let in_B3 = 'B3 + 18'
let in_B2 = 'B2 + 16'
let in_B1 = 'B1 + 14'
let in_B0 = 'B0 + 12'

let in_Cin = 'Cin + 10'

let out_Cout = 'C3 + 8'
let out_S3 = 'S3 + 6'
let out_S2 = 'S2 + 4'
let out_S1 = 'S1 + 2'
let out_S0 = 'S0'

* plot in_A3 in_A2 in_A1 in_A0 in_B3 in_B2 in_B1 in_B0 in_Cin out_Cout out_S3 out_S2 out_S1 out_S0
plot (B0 + 12) out_Cout out_S3 out_S2 out_S1 out_S0
* plot

.endc

.end
