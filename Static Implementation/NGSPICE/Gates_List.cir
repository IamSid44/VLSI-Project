.subckt Inverter in out high low

    .param width_N_Inverter = {1.1 * width_N}
    .param width_P_Inverter = {1.1 * width_P}

    M1 high in out high CMOSP W={width_P_Inverter} L={2*LAMBDA}
    + AS={5*width_P_Inverter*LAMBDA} PS={10*LAMBDA+2*width_P_Inverter} AD={5*width_P_Inverter*LAMBDA} PD={10*LAMBDA+2*width_P_Inverter}
    M2 out in low low CMOSN W={width_N_Inverter} L={2*LAMBDA}
    + AS={5*width_N_Inverter*LAMBDA} PS={10*LAMBDA+2*width_N_Inverter} AD={5*width_N_Inverter*LAMBDA} PD={10*LAMBDA+2*width_N_Inverter}

.ends Inverter

.subckt Small_NOR_Gate A B out high low

    .param width_P_NOR = {0.5 * width_P}
    .param width_N_NOR = {0.5 * width_N}

    MPUN_01 high A NOR_Inter high CMOSP W={width_P_NOR} L={2*LAMBDA}
    + AS={5*width_P_NOR*LAMBDA} PS={10*LAMBDA+2*width_P_NOR} AD={5*width_P_NOR*LAMBDA} PD={10*LAMBDA+2*width_P_NOR}

    MPUN_02 NOR_Inter B out NOR_Inter CMOSP W={width_P_NOR} L={2*LAMBDA}
    + AS={5*width_P_NOR*LAMBDA} PS={10*LAMBDA+2*width_P_NOR} AD={5*width_P_NOR*LAMBDA} PD={10*LAMBDA+2*width_P_NOR}

    MPDN_01 out A low low CMOSN W={width_N_NOR} L={2*LAMBDA}
    + AS={5*width_N_NOR*LAMBDA} PS={10*LAMBDA+2*width_N_NOR} AD={5*width_N_NOR*LAMBDA} PD={10*LAMBDA+2*width_N_NOR}

    MPDN_02 out B low low CMOSN W={width_N_NOR} L={2*LAMBDA}
    + AS={5*width_N_NOR*LAMBDA} PS={10*LAMBDA+2*width_N_NOR} AD={5*width_N_NOR*LAMBDA} PD={10*LAMBDA+2*width_N_NOR}

.ends Small_NOR_Gate

.subckt Medium_NOR_Gate A B out high low

    .param width_N_NOR = {2 * width_N}
    .param width_P_NOR = {2 * width_P}

    MPUN_01 high A NOR_Inter high CMOSP W={width_P_NOR} L={2*LAMBDA}
    + AS={5*width_P_NOR*LAMBDA} PS={10*LAMBDA+2*width_P_NOR} AD={5*width_P_NOR*LAMBDA} PD={10*LAMBDA+2*width_P_NOR}

    MPUN_02 NOR_Inter B out NOR_Inter CMOSP W={width_P_NOR} L={2*LAMBDA}
    + AS={5*width_P_NOR*LAMBDA} PS={10*LAMBDA+2*width_P_NOR} AD={5*width_P_NOR*LAMBDA} PD={10*LAMBDA+2*width_P_NOR}

    MPDN_01 out A low low CMOSN W={width_N_NOR} L={2*LAMBDA}
    + AS={5*width_N_NOR*LAMBDA} PS={10*LAMBDA+2*width_N_NOR} AD={5*width_N_NOR*LAMBDA} PD={10*LAMBDA+2*width_N_NOR}

    MPDN_02 out B low low CMOSN W={width_N_NOR} L={2*LAMBDA}
    + AS={5*width_N_NOR*LAMBDA} PS={10*LAMBDA+2*width_N_NOR} AD={5*width_N_NOR*LAMBDA} PD={10*LAMBDA+2*width_N_NOR}

.ends Medium_NOR_Gate

.subckt Bigger_NOR_Gate A B out high low

    .param width_N_NOR = {4 * width_N}
    .param width_P_NOR = {4 * width_P}

    MPUN_01 high A NOR_Inter high CMOSP W={width_P_NOR} L={2*LAMBDA}
    + AS={5*width_P_NOR*LAMBDA} PS={10*LAMBDA+2*width_P_NOR} AD={5*width_P_NOR*LAMBDA} PD={10*LAMBDA+2*width_P_NOR}

    MPUN_02 NOR_Inter B out NOR_Inter CMOSP W={width_P_NOR} L={2*LAMBDA}
    + AS={5*width_P_NOR*LAMBDA} PS={10*LAMBDA+2*width_P_NOR} AD={5*width_P_NOR*LAMBDA} PD={10*LAMBDA+2*width_P_NOR}

    MPDN_01 out A low low CMOSN W={width_N_NOR} L={2*LAMBDA}
    + AS={5*width_N_NOR*LAMBDA} PS={10*LAMBDA+2*width_N_NOR} AD={5*width_N_NOR*LAMBDA} PD={10*LAMBDA+2*width_N_NOR}

    MPDN_02 out B low low CMOSN W={width_N_NOR} L={2*LAMBDA}
    + AS={5*width_N_NOR*LAMBDA} PS={10*LAMBDA+2*width_N_NOR} AD={5*width_N_NOR*LAMBDA} PD={10*LAMBDA+2*width_N_NOR}

.ends Bigger_NOR_Gate

.subckt OR_Gate A B out high low

    XNOR A B out_inter high low Medium_NOR_Gate
    XInverter out_inter out high low Inverter

.ends OR_Gate

.subckt NAND_Gate A B out high low

    .param width_N_NAND = {2 * width_N}
    .param width_P_NAND = {1 * width_P}

    MPUN_01 high A out high CMOSP W={width_P_NAND} L={2*LAMBDA}
    + AS={5*width_P_NAND*LAMBDA} PS={10*LAMBDA+2*width_P_NAND} AD={5*width_P_NAND*LAMBDA} PD={10*LAMBDA+2*width_P_NAND}

    MPUN_02 high B out high CMOSP W={width_P_NAND} L={2*LAMBDA}
    + AS={5*width_P_NAND*LAMBDA} PS={10*LAMBDA+2*width_P_NAND} AD={5*width_P_NAND*LAMBDA} PD={10*LAMBDA+2*width_P_NAND}

    MPDN_01 out A NAND_PDN_Inter NAND_PDN_Inter CMOSN W={width_N_NAND} L={2*LAMBDA}
    + AS={5*width_N_NAND*LAMBDA} PS={10*LAMBDA+2*width_N_NAND} AD={5*width_N_NAND*LAMBDA} PD={10*LAMBDA+2*width_N_NAND}

    MPDN_02 NAND_PDN_Inter B low low CMOSN W={width_N_NAND} L={2*LAMBDA}
    + AS={5*width_N_NAND*LAMBDA} PS={10*LAMBDA+2*width_N_NAND} AD={5*width_N_NAND*LAMBDA} PD={10*LAMBDA+2*width_N_NAND}

.ends NAND_Gate

.subckt Bigger_NAND_Gate A B out high low

    .param width_N_NAND = {4 * width_N}
    .param width_P_NAND = {2 * width_P}

    MPUN_01 high A out high CMOSP W={width_P_NAND} L={2*LAMBDA}
    + AS={5*width_P_NAND*LAMBDA} PS={10*LAMBDA+2*width_P_NAND} AD={5*width_P_NAND*LAMBDA} PD={10*LAMBDA+2*width_P_NAND}

    MPUN_02 high B out high CMOSP W={width_P_NAND} L={2*LAMBDA}
    + AS={5*width_P_NAND*LAMBDA} PS={10*LAMBDA+2*width_P_NAND} AD={5*width_P_NAND*LAMBDA} PD={10*LAMBDA+2*width_P_NAND}

    MPDN_01 out A NAND_PDN_Inter NAND_PDN_Inter CMOSN W={width_N_NAND} L={2*LAMBDA}
    + AS={5*width_N_NAND*LAMBDA} PS={10*LAMBDA+2*width_N_NAND} AD={5*width_N_NAND*LAMBDA} PD={10*LAMBDA+2*width_N_NAND}

    MPDN_02 NAND_PDN_Inter B low low CMOSN W={width_N_NAND} L={2*LAMBDA}
    + AS={5*width_N_NAND*LAMBDA} PS={10*LAMBDA+2*width_N_NAND} AD={5*width_N_NAND*LAMBDA} PD={10*LAMBDA+2*width_N_NAND}

.ends Bigger_NAND_Gate

.subckt AND_Gate A B out high low

    XNAND A B out_inter high low NAND_Gate
    XInverter out_inter out high low Inverter

.ends AND_Gate

.subckt XOR_Gate A A_not B out high low

    .param width_N_XOR = {0.5 * width_N}
    .param width_P_XOR = {0.5 * width_P}

    * Inverter logic - Careful with the body nodes
    M3 A B out high CMOSP W={width_P_XOR} L={2*LAMBDA}
    + AS={5*width_P_XOR*LAMBDA} PS={10*LAMBDA+2*width_P_XOR} AD={5*width_P_XOR*LAMBDA} PD={10*LAMBDA+2*width_P_XOR}
    M4 out B A_not low CMOSN W={width_N_XOR} L={2*LAMBDA}
    + AS={5*width_N_XOR*LAMBDA} PS={10*LAMBDA+2*width_N_XOR} AD={5*width_N_XOR*LAMBDA} PD={10*LAMBDA+2*width_N_XOR}

    * Analog Transmission gate
    M1 out A B high CMOSP W={0.5*width_P_XOR} L={2*LAMBDA}
    + AS={5*0.5*width_P_XOR*LAMBDA} PS={10*LAMBDA+2*0.5*width_P_XOR} AD={5*0.5*width_P_XOR*LAMBDA} PD={10*LAMBDA+2*0.5*width_P_XOR}
    M2 out A_not B low CMOSN W={0.5*width_N_XOR} L={2*LAMBDA}
    + AS={5*0.5*width_N_XOR*LAMBDA} PS={10*LAMBDA+2*0.5*width_N_XOR} AD={5*0.5*width_N_XOR*LAMBDA} PD={10*LAMBDA+2*0.5*width_N_XOR}

.ends XOR_Gate
