NGSPICE Netlist for combining all the elements to make a 4 Bit CLA

.include "TSMC_180nm.txt"
.param SUPPLY = 1.8
.param LAMBDA = 0.09u
.param width_N = {20 * LAMBDA} ; Vary the width (1)
.param width_P = {2 * width_N} ; Assuming ratio of mobilites is 2, change it (2)
.global gnd vdd

.include "Sub_Circuits.cir"

.subckt CLA_4_Bit clk A3_not A2_not A1_not A0_not B3_not B2_not B1_not B0_not Cin_not S3 S2 S1 S0 C3 high low

    XCarry0 clk A0_not B0_not Cin_not C0 high low C0_Bit_Logic
    XCarry1 clk A1_not A0_not B1_not B0_not Cin_not C1 high low C1_Bit_Logic
    XCarry2 clk A2_not A1_not A0_not B2_not B1_not B0_not Cin_not C2 high low C2_Bit_Logic
    XCarry3 clk A3_not A2_not A1_not A0_not B3_not B2_not B1_not B0_not Cin_not C3 high low C3_Bit_Logic

    XInvClk clk clk_not high low Inverter
    XInv0 C0 C0_not high low Inverter
    XInv1 C1 C1_not high low Inverter
    XInv2 C2 C2_not high low Inverter
    XInv3 C3 C3_not high low Inverter

    XSum0 clk_not A0_not B0_not Cin_not C0 S0 high low Sum_Bit_Logic
    XSum1 clk_not A1_not B1_not C0_not C1 S1 high low Sum_Bit_Logic
    XSum2 clk_not A2_not B2_not C1_not C2 S2 high low Sum_Bit_Logic
    XSum3 clk_not A3_not B3_not C2_not C3 S3 high low Sum_Bit_Logic

.ends CLA_4_Bit

* .subckt InverterLoad in out high low
*     M1 high in out high CMOSP W={20*LAMBDA} L={2*LAMBDA}
*     + AS={5*20*LAMBDA*LAMBDA} PS={10*LAMBDA+2*20*LAMBDA} AD={5*20*LAMBDA*LAMBDA} PD={10*LAMBDA+2*20*LAMBDA}
*     M2 out in low low CMOSN W={10*LAMBDA} L={2*LAMBDA}
*     + AS={5*10*LAMBDA*LAMBDA} PS={10*LAMBDA+2*10*LAMBDA} AD={5*10*LAMBDA*LAMBDA} PD={10*LAMBDA+2*10*LAMBDA}
* .ends InverterLoad

* vin in+ in- pulse VLow VHigh delay rise-time fall-time on-period time-period
VDD vdd gnd 'SUPPLY'

VClk clk_line gnd pulse gnd SUPPLY 0.5n 1p 1p 1ns 2ns ; No Skew Currently, add a skew for practical measurements (3)

* VA3_not A3_not gnd pulse gnd SUPPLY 0 1p 1p 1ns 2ns ; No Skew Currently, add a skew for practical measurements (4)
* VA2_not A2_not gnd pulse gnd SUPPLY 0 1p 1p 1ns 2ns ; No Skew Currently, add a skew for practical measurements (5)
* VA1_not A1_not gnd pulse gnd SUPPLY 0 1p 1p 1ns 2ns ; No Skew Currently, add a skew for practical measurements (6)
* VA0_not A0_not gnd pulse gnd SUPPLY 0 1p 1p 1ns 2ns ; No Skew Currently, add a skew for practical measurements (7)

* VB3_not B3_not gnd pulse gnd SUPPLY 0 1p 1p 1ns 2ns ; No Skew Currently, add a skew for practical measurements (8)
* VB2_not B2_not gnd pulse gnd SUPPLY 0 1p 1p 1ns 2ns ; No Skew Currently, add a skew for practical measurements (9)
* VB1_not B1_not gnd pulse gnd SUPPLY 0 1p 1p 1ns 2ns ; No Skew Currently, add a skew for practical measurements (10)
* VB0_not B0_not gnd pulse gnd SUPPLY 0 1p 1p 1ns 2ns ; No Skew Currently, add a skew for practical measurements (11)

* VCin_not Cin_not gnd pulse gnd SUPPLY 0 1p 1p 1ns 2ns ; No Skew Currently, add a skew for practical measurements (12)

* Test Case 1010 + 0101 + 0 = 01011

VA3_not A3_not gnd 'SUPPLY'
VA2_not A2_not gnd 0
VA1_not A1_not gnd 'SUPPLY'
VA0_not A0_not gnd 0

VB3_not B3_not gnd 0
VB2_not B2_not gnd 'SUPPLY'
VB1_not B1_not gnd 0
VB0_not B0_not gnd 'SUPPLY'

VCin_not Cin_not gnd 0

    XCarry0 clk_line A0_not B0_not Cin_not C0 vdd gnd C0_Bit_Logic
    XCarry1 clk_line A1_not A0_not B1_not B0_not Cin_not C1 vdd gnd C1_Bit_Logic
    XCarry2 clk_line A2_not A1_not A0_not B2_not B1_not B0_not Cin_not C2 vdd gnd C2_Bit_Logic
    XCarry3 clk_line A3_not A2_not A1_not A0_not B3_not B2_not B1_not B0_not Cin_not C3 vdd gnd C3_Bit_Logic

    XLatchC0 C0 Latched_C0 clk_line vdd gnd TSPC_Latch_HighLevel
    XLatchC1 C1 Latched_C1 clk_line vdd gnd TSPC_Latch_HighLevel
    XLatchC2 C2 Latched_C2 clk_line vdd gnd TSPC_Latch_HighLevel
    XLatchC3 C3 Latched_C3 clk_line vdd gnd TSPC_Latch_HighLevel

    XInvClk clk_line clk_not vdd gnd Inverter
    XInv0 Latched_C0 C0_not vdd gnd Inverter
    XInv1 Latched_C1 C1_not vdd gnd Inverter
    XInv2 Latched_C2 C2_not vdd gnd Inverter
    XInv3 Latched_C3 C3_not vdd gnd Inverter ; Can Take LITE

    XSum0 clk_not A0_not B0_not Cin_not Latched_C0 S0 vdd gnd Sum_Bit_Logic
    XSum1 clk_not A1_not B1_not C0_not Latched_C1 S1 vdd gnd Sum_Bit_Logic
    XSum2 clk_not A2_not B2_not C1_not Latched_C2 S2 vdd gnd Sum_Bit_Logic
    XSum3 clk_not A3_not B3_not C2_not Latched_C3 S3 vdd gnd Sum_Bit_Logic

* XCLA clk_line A3_not A2_not A1_not A0_not B3_not B2_not B1_not B0_not Cin_not S3 S2 S1 S0 Cout high low CLA_4_Bit

* Load - (13)
* XInverterL out temp vdd gnd InverterLoad

* .measure tran trise
* + TRIG V(out) VAL = 'SUPPLY / 10' TD = 5ns TO = 15ns RISE = 1
* + TARG V(out) VAL = '9 * SUPPLY / 10' TD = 5ns TO = 15ns RISE = 1

* .measure tran tfall
* + TRIG V(out) VAL = '9 * SUPPLY / 10' TD = 25ns TO = 35ns FALL = 1
* + TARG V(out) VAL = 'SUPPLY / 10' TD = 25ns TO = 35ns FALL = 1

* .measure tran delay param = '(trise + tfall) / 2'

* .measure tran tcqrise
* + TRIG V(clk_line) VAL = 'SUPPLY / 2' RISE = 1
* + TARG V(out) VAL = 'SUPPLY / 2' RISE = 1

* .measure tran tcqfall
* + TRIG V(clk_line) VAL = 'SUPPLY / 2' RISE = 2
* + TARG V(out) VAL = 'SUPPLY / 2' FALL = 1

* .measure tran tcq param = '(tcqrise + tcqfall) / 2'

.tran 10ps 16ns

Xtempinv Cin_not Cin vdd gnd Inverter

.control

run
set hcopypscolor = 1
set color0 = white
set color1 = black
set curplottitle = "Siddarth Gottumukkula 2023102040"
set xbrushwidth = 3
set ybrushwidth = 3

let clock = 'clk_line + 28'
let in_a3_bar = 'A3_not + 26'
let in_a2_bar = 'A2_not + 24'
let in_a1_bar = 'A1_not + 22'
let in_a0_bar = 'A0_not + 20'
let in_b3_bar = 'B3_not + 18'
let in_b2_bar = 'B2_not + 16'
let in_b1_bar = 'B1_not + 14'
let in_b0_bar = 'B0_not + 12'
let in_cin_bar = 'Cin_not + 10'
let out_Cout = 'Latched_C3 + 8'
let out_S3 = 'S3 + 6'
let out_S2 = 'S2 + 4'
let out_S1 = 'S1 + 2'
let out_S0 = 'S0'

plot clock in_a3_bar in_a2_bar in_a1_bar in_a0_bar in_b3_bar in_b2_bar in_b1_bar in_b0_bar in_cin_bar out_Cout out_S3 out_S2 out_S1 out_S0

let latch_c0 = 'Latched_C0 + 26'
let latch_c1 = 'Latched_C1 + 24'
let latch_c2 = 'Latched_C2 + 22'
let latch_c3 = 'Latched_C3 + 20'
let temp_Cin = 'Cin + 18'
let temp_C0 = 'C0 + 16'
let temp_C1 = 'C1 + 14'
let temp_C2 = 'C2 + 12'
let temp_C3 = 'C3 + 10'
let temp_Cin_not = 'Cin_not + 8'
let temp_c0_not = 'C0_not + 6'
let temp_c1_not = 'C1_not + 4'
let temp_c2_not = 'C2_not + 2'
let temp_c3_not = 'C3_not'

plot clock temp_Cin temp_C0 temp_C1 temp_C2 temp_C3 temp_Cin_not temp_c0_not temp_c1_not temp_c2_not temp_c3_not latch_c0 latch_c1 latch_c2 latch_c3

.endc

.end
